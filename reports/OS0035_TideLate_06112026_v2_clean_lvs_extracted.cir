* Extracted by KLayout with SCL C1D LVS runset on : 07/11/2026 15:55

* cell OS0035
* pin VSS
.SUBCKT OS0035 VSS
* cell instance $1 r0 *1 0,0
X$1 \$31 \$34 \$34 \$34 \$34 \$34 \$34 \$34 VSS frame2mmx2mm
* cell instance $2 r0 *1 0,0
X$2 \$34 VSS \$31 \$31 \$31 \$31 \$31 \$31 \$31 \$31 \$31 \$31 \$31 \$31 \$31
+ \$31 \$31 \$31 \$31 \$31 \$31 \$31 \$31 \$31 \$31 \$31 \$31 \$31 tide_late
.ENDS OS0035

* cell tide_late
* pin clk,done,rst_n,sdi,sdo,sh_en,start
* pin VSS
* pin
* pin
* pin
* pin
* pin
* pin
* pin
* pin
* pin
* pin
* pin
* pin
* pin
* pin
* pin
* pin
* pin
* pin
* pin
* pin
* pin
* pin
* pin
* pin
* pin
* pin
.SUBCKT tide_late clk|done|rst_n|sdi|sdo|sh_en|start VSS \$I6833 \$I6832
+ \$I6830 \$I6827 \$I6823 \$I6819 \$I6818 \$I6814 \$I6812 \$I6808 \$I6796
+ \$I6789 \$I6788 \$I6781 \$I6775 \$I6760 \$I6730 \$I6725 \$I2828 \$I2783
+ \$I2762 \$I2758 \$I2747 \$I2745 \$I2572 \$I2245
* cell instance $1 r0 *1 388.2,328.4
X$1 clk|done|rst_n|sdi|sdo|sh_en|start clk|done|rst_n|sdi|sdo|sh_en|start
+ clk|done|rst_n|sdi|sdo|sh_en|start clk|done|rst_n|sdi|sdo|sh_en|start \$I2245
+ VSS MX2100
* cell instance $2 r0 *1 419.4,328.4
X$2 clk|done|rst_n|sdi|sdo|sh_en|start clk|done|rst_n|sdi|sdo|sh_en|start
+ clk|done|rst_n|sdi|sdo|sh_en|start \$I9996 \$I2245 VSS DFFL11
* cell instance $3 r0 *1 743.1,328.4
X$3 \$7 clk|done|rst_n|sdi|sdo|sh_en|start \$28
+ clk|done|rst_n|sdi|sdo|sh_en|start \$I2245 VSS MX2100
* cell instance $4 r0 *1 774.3,328.4
X$4 \$I2245 clk|done|rst_n|sdi|sdo|sh_en|start
+ clk|done|rst_n|sdi|sdo|sh_en|start VSS BUFF00
* cell instance $5 r0 *1 1386.6,328.4
X$5 \$I2245 clk|done|rst_n|sdi|sdo|sh_en|start
+ clk|done|rst_n|sdi|sdo|sh_en|start clk|done|rst_n|sdi|sdo|sh_en|start VSS
+ NND200
* cell instance $6 r0 *1 419.4,379.1
X$6 \$72 clk|done|rst_n|sdi|sdo|sh_en|start clk|done|rst_n|sdi|sdo|sh_en|start
+ clk|done|rst_n|sdi|sdo|sh_en|start clk|done|rst_n|sdi|sdo|sh_en|start
+ clk|done|rst_n|sdi|sdo|sh_en|start clk|done|rst_n|sdi|sdo|sh_en|start \$I2572
+ VSS MX4100
* cell instance $7 r0 *1 1137,328.4
X$7 \$I2245 \$48 clk|done|rst_n|sdi|sdo|sh_en|start
+ clk|done|rst_n|sdi|sdo|sh_en|start VSS NOR200
* cell instance $8 r0 *1 1293,328.4
X$8 \$I2245 clk|done|rst_n|sdi|sdo|sh_en|start \$15
+ clk|done|rst_n|sdi|sdo|sh_en|start \$123 VSS ORND00
* cell instance $9 r0 *1 1062.9,429.8
X$9 \$I2762 \$244 clk|done|rst_n|sdi|sdo|sh_en|start
+ clk|done|rst_n|sdi|sdo|sh_en|start clk|done|rst_n|sdi|sdo|sh_en|start
+ clk|done|rst_n|sdi|sdo|sh_en|start VSS AOI400
* cell instance $10 r0 *1 637.8,379.1
X$10 \$79 \$28 clk|done|rst_n|sdi|sdo|sh_en|start
+ clk|done|rst_n|sdi|sdo|sh_en|start clk|done|rst_n|sdi|sdo|sh_en|start
+ clk|done|rst_n|sdi|sdo|sh_en|start clk|done|rst_n|sdi|sdo|sh_en|start \$I2572
+ VSS MX4100
* cell instance $11 r0 *1 1312.5,429.8
X$11 \$I2762 clk|done|rst_n|sdi|sdo|sh_en|start \$255 \$195
+ clk|done|rst_n|sdi|sdo|sh_en|start clk|done|rst_n|sdi|sdo|sh_en|start VSS
+ NND400
* cell instance $12 r0 *1 1098,429.8
X$12 \$I2762 clk|done|rst_n|sdi|sdo|sh_en|start \$244 \$185
+ clk|done|rst_n|sdi|sdo|sh_en|start clk|done|rst_n|sdi|sdo|sh_en|start VSS
+ NND400
* cell instance $13 r0 *1 1281.3,429.8
X$13 \$I2762 \$255 clk|done|rst_n|sdi|sdo|sh_en|start
+ clk|done|rst_n|sdi|sdo|sh_en|start clk|done|rst_n|sdi|sdo|sh_en|start
+ clk|done|rst_n|sdi|sdo|sh_en|start VSS AOI400
* cell instance $14 r0 *1 1148.7,531.2
X$14 clk|done|rst_n|sdi|sdo|sh_en|start clk|done|rst_n|sdi|sdo|sh_en|start
+ clk|done|rst_n|sdi|sdo|sh_en|start \$I2745 VSS XNR200
* cell instance $15 r0 *1 1191.6,531.2
X$15 clk|done|rst_n|sdi|sdo|sh_en|start clk|done|rst_n|sdi|sdo|sh_en|start
+ \$I2745 clk|done|rst_n|sdi|sdo|sh_en|start clk|done|rst_n|sdi|sdo|sh_en|start
+ VSS ADNR00
* cell instance $16 r0 *1 1215,581.9
X$16 \$I2828 clk|done|rst_n|sdi|sdo|sh_en|start
+ clk|done|rst_n|sdi|sdo|sh_en|start clk|done|rst_n|sdi|sdo|sh_en|start
+ clk|done|rst_n|sdi|sdo|sh_en|start VSS NOR300
* cell instance $17 r0 *1 1523.1,531.2
X$17 \$I2745 \$475 clk|done|rst_n|sdi|sdo|sh_en|start
+ clk|done|rst_n|sdi|sdo|sh_en|start clk|done|rst_n|sdi|sdo|sh_en|start VSS
+ NND300
* cell instance $18 r0 *1 1250.1,581.9
X$18 \$I2828 \$578 clk|done|rst_n|sdi|sdo|sh_en|start
+ clk|done|rst_n|sdi|sdo|sh_en|start clk|done|rst_n|sdi|sdo|sh_en|start VSS
+ OR3100
* cell instance $19 r0 *1 1343.7,581.9
X$19 clk|done|rst_n|sdi|sdo|sh_en|start \$508
+ clk|done|rst_n|sdi|sdo|sh_en|start clk|done|rst_n|sdi|sdo|sh_en|start
+ clk|done|rst_n|sdi|sdo|sh_en|start \$I2828 VSS NOR400
* cell instance $20 r0 *1 1129.2,581.9
X$20 \$I2828 clk|done|rst_n|sdi|sdo|sh_en|start
+ clk|done|rst_n|sdi|sdo|sh_en|start \$393 VSS AND200
* cell instance $21 r0 *1 1191.6,632.6
X$21 clk|done|rst_n|sdi|sdo|sh_en|start clk|done|rst_n|sdi|sdo|sh_en|start
+ clk|done|rst_n|sdi|sdo|sh_en|start \$I6781 VSS OR2100
* cell instance $22 r0 *1 832.8,1139.6
X$22 \$I6814 clk|done|rst_n|sdi|sdo|sh_en|start \$1675
+ clk|done|rst_n|sdi|sdo|sh_en|start clk|done|rst_n|sdi|sdo|sh_en|start VSS
+ AND300
* cell instance $23 r0 *1 1277.4,987.5
X$23 clk|done|rst_n|sdi|sdo|sh_en|start clk|done|rst_n|sdi|sdo|sh_en|start
+ clk|done|rst_n|sdi|sdo|sh_en|start clk|done|rst_n|sdi|sdo|sh_en|start
+ clk|done|rst_n|sdi|sdo|sh_en|start clk|done|rst_n|sdi|sdo|sh_en|start \$I6725
+ VSS AND500
* cell instance $24 r0 *1 1257.9,1038.2
X$24 \$I6775 clk|done|rst_n|sdi|sdo|sh_en|start \$1433 \$1432
+ clk|done|rst_n|sdi|sdo|sh_en|start clk|done|rst_n|sdi|sdo|sh_en|start VSS
+ OAI400
* cell instance $25 r0 *1 1269.6,1190.3
X$25 clk|done|rst_n|sdi|sdo|sh_en|start clk|done|rst_n|sdi|sdo|sh_en|start
+ clk|done|rst_n|sdi|sdo|sh_en|start clk|done|rst_n|sdi|sdo|sh_en|start
+ clk|done|rst_n|sdi|sdo|sh_en|start \$I6808 VSS OR4100
* cell instance $26 r0 *1 1172.1,1038.2
X$26 clk|done|rst_n|sdi|sdo|sh_en|start clk|done|rst_n|sdi|sdo|sh_en|start
+ clk|done|rst_n|sdi|sdo|sh_en|start \$1432 clk|done|rst_n|sdi|sdo|sh_en|start
+ \$I6775 VSS DFCL11
* cell instance $27 r0 *1 1452.9,1038.2
X$27 \$1441 clk|done|rst_n|sdi|sdo|sh_en|start \$1605
+ clk|done|rst_n|sdi|sdo|sh_en|start \$I6775 VSS DFFL11
* cell instance $28 r0 *1 821.1,1342.4
X$28 clk|done|rst_n|sdi|sdo|sh_en|start clk|done|rst_n|sdi|sdo|sh_en|start
+ clk|done|rst_n|sdi|sdo|sh_en|start clk|done|rst_n|sdi|sdo|sh_en|start
+ clk|done|rst_n|sdi|sdo|sh_en|start \$I6823 VSS AND400
* cell instance $29 r0 *1 938.1,1342.4
X$29 clk|done|rst_n|sdi|sdo|sh_en|start clk|done|rst_n|sdi|sdo|sh_en|start
+ clk|done|rst_n|sdi|sdo|sh_en|start clk|done|rst_n|sdi|sdo|sh_en|start \$I6823
+ VSS XOR300
* cell instance $30 r0 *1 1488,1342.4
X$30 clk|done|rst_n|sdi|sdo|sh_en|start clk|done|rst_n|sdi|sdo|sh_en|start
+ clk|done|rst_n|sdi|sdo|sh_en|start \$1657 \$2320
+ clk|done|rst_n|sdi|sdo|sh_en|start \$I6823 VSS NND500
* cell instance $31 r0 *1 856.2,1494.5
X$31 clk|done|rst_n|sdi|sdo|sh_en|start clk|done|rst_n|sdi|sdo|sh_en|start
+ clk|done|rst_n|sdi|sdo|sh_en|start clk|done|rst_n|sdi|sdo|sh_en|start
+ clk|done|rst_n|sdi|sdo|sh_en|start clk|done|rst_n|sdi|sdo|sh_en|start \$I6833
+ VSS NND500
* cell instance $32 r0 *1 848.4,1545.2
X$32 clk|done|rst_n|sdi|sdo|sh_en|start \$2539
+ clk|done|rst_n|sdi|sdo|sh_en|start clk|done|rst_n|sdi|sdo|sh_en|start \$2647
+ \$2647 \$I6832 VSS NND500
* cell instance $33 r0 *1 840.6,1393.1
X$33 clk|done|rst_n|sdi|sdo|sh_en|start clk|done|rst_n|sdi|sdo|sh_en|start
+ clk|done|rst_n|sdi|sdo|sh_en|start clk|done|rst_n|sdi|sdo|sh_en|start \$I6830
+ VSS XOR300
* cell instance $34 r0 *1 719.7,1545.2
X$34 clk|done|rst_n|sdi|sdo|sh_en|start clk|done|rst_n|sdi|sdo|sh_en|start
+ clk|done|rst_n|sdi|sdo|sh_en|start clk|done|rst_n|sdi|sdo|sh_en|start \$I6832
+ VSS XOR300
* cell instance $35 r0 *1 938.1,1545.2
X$35 clk|done|rst_n|sdi|sdo|sh_en|start clk|done|rst_n|sdi|sdo|sh_en|start
+ \$2511 \$2608 \$I6832 VSS XOR300
* cell instance $36 r0 *1 610.5,1393.1
X$36 clk|done|rst_n|sdi|sdo|sh_en|start clk|done|rst_n|sdi|sdo|sh_en|start
+ clk|done|rst_n|sdi|sdo|sh_en|start clk|done|rst_n|sdi|sdo|sh_en|start
+ clk|done|rst_n|sdi|sdo|sh_en|start \$I6830 VSS AND400
* cell instance $37 r0 *1 1066.8,1595.9
X$37 clk|done|rst_n|sdi|sdo|sh_en|start clk|done|rst_n|sdi|sdo|sh_en|start
+ \$2728 clk|done|rst_n|sdi|sdo|sh_en|start clk|done|rst_n|sdi|sdo|sh_en|start
+ \$I6827 VSS AND400
* cell instance $38 r0 *1 1008.3,1393.1
X$38 clk|done|rst_n|sdi|sdo|sh_en|start clk|done|rst_n|sdi|sdo|sh_en|start
+ clk|done|rst_n|sdi|sdo|sh_en|start clk|done|rst_n|sdi|sdo|sh_en|start
+ clk|done|rst_n|sdi|sdo|sh_en|start \$I6830 VSS AND400
* cell instance $39 r0 *1 895.2,1595.9
X$39 clk|done|rst_n|sdi|sdo|sh_en|start clk|done|rst_n|sdi|sdo|sh_en|start
+ clk|done|rst_n|sdi|sdo|sh_en|start clk|done|rst_n|sdi|sdo|sh_en|start
+ clk|done|rst_n|sdi|sdo|sh_en|start \$I6827 VSS AND400
* cell instance $40 r0 *1 949.8,1494.5
X$40 clk|done|rst_n|sdi|sdo|sh_en|start clk|done|rst_n|sdi|sdo|sh_en|start
+ clk|done|rst_n|sdi|sdo|sh_en|start clk|done|rst_n|sdi|sdo|sh_en|start
+ clk|done|rst_n|sdi|sdo|sh_en|start \$I6833 VSS AND400
* cell instance $41 r0 *1 1394.4,1342.4
X$41 clk|done|rst_n|sdi|sdo|sh_en|start clk|done|rst_n|sdi|sdo|sh_en|start
+ clk|done|rst_n|sdi|sdo|sh_en|start clk|done|rst_n|sdi|sdo|sh_en|start
+ clk|done|rst_n|sdi|sdo|sh_en|start \$I6823 VSS OR4100
* cell instance $42 r0 *1 1218.9,1393.1
X$42 \$I6830 clk|done|rst_n|sdi|sdo|sh_en|start
+ clk|done|rst_n|sdi|sdo|sh_en|start clk|done|rst_n|sdi|sdo|sh_en|start
+ clk|done|rst_n|sdi|sdo|sh_en|start VSS AND300
* cell instance $43 r0 *1 1558.2,1342.4
X$43 \$I6823 clk|done|rst_n|sdi|sdo|sh_en|start
+ clk|done|rst_n|sdi|sdo|sh_en|start clk|done|rst_n|sdi|sdo|sh_en|start
+ clk|done|rst_n|sdi|sdo|sh_en|start VSS AND300
* cell instance $44 r0 *1 1558.2,1443.8
X$44 \$I6819 clk|done|rst_n|sdi|sdo|sh_en|start
+ clk|done|rst_n|sdi|sdo|sh_en|start clk|done|rst_n|sdi|sdo|sh_en|start
+ clk|done|rst_n|sdi|sdo|sh_en|start VSS AND300
* cell instance $45 r0 *1 766.5,1241
X$45 \$I6818 clk|done|rst_n|sdi|sdo|sh_en|start
+ clk|done|rst_n|sdi|sdo|sh_en|start clk|done|rst_n|sdi|sdo|sh_en|start
+ clk|done|rst_n|sdi|sdo|sh_en|start VSS AND300
* cell instance $46 r0 *1 1530.9,1443.8
X$46 \$I6819 clk|done|rst_n|sdi|sdo|sh_en|start
+ clk|done|rst_n|sdi|sdo|sh_en|start clk|done|rst_n|sdi|sdo|sh_en|start \$2349
+ VSS AND300
* cell instance $47 r0 *1 1246.2,1393.1
X$47 \$I6830 clk|done|rst_n|sdi|sdo|sh_en|start
+ clk|done|rst_n|sdi|sdo|sh_en|start clk|done|rst_n|sdi|sdo|sh_en|start
+ clk|done|rst_n|sdi|sdo|sh_en|start VSS AND300
* cell instance $48 r0 *1 1363.2,1342.4
X$48 \$I6823 clk|done|rst_n|sdi|sdo|sh_en|start
+ clk|done|rst_n|sdi|sdo|sh_en|start clk|done|rst_n|sdi|sdo|sh_en|start
+ clk|done|rst_n|sdi|sdo|sh_en|start VSS AND300
* cell instance $49 r0 *1 973.2,1393.1
X$49 \$I6830 \$2277 clk|done|rst_n|sdi|sdo|sh_en|start \$2279
+ clk|done|rst_n|sdi|sdo|sh_en|start VSS AND300
* cell instance $50 r0 *1 1460.7,1190.3
X$50 \$1862 clk|done|rst_n|sdi|sdo|sh_en|start
+ clk|done|rst_n|sdi|sdo|sh_en|start clk|done|rst_n|sdi|sdo|sh_en|start \$I6808
+ VSS DFFL11
* cell instance $51 r0 *1 1460.7,1139.6
X$51 clk|done|rst_n|sdi|sdo|sh_en|start clk|done|rst_n|sdi|sdo|sh_en|start
+ clk|done|rst_n|sdi|sdo|sh_en|start clk|done|rst_n|sdi|sdo|sh_en|start \$I6814
+ VSS DFFL11
* cell instance $52 r0 *1 930.3,1139.6
X$52 clk|done|rst_n|sdi|sdo|sh_en|start clk|done|rst_n|sdi|sdo|sh_en|start
+ clk|done|rst_n|sdi|sdo|sh_en|start clk|done|rst_n|sdi|sdo|sh_en|start \$I6814
+ VSS DFFL11
* cell instance $53 r0 *1 1109.7,1595.9
X$53 clk|done|rst_n|sdi|sdo|sh_en|start clk|done|rst_n|sdi|sdo|sh_en|start
+ clk|done|rst_n|sdi|sdo|sh_en|start clk|done|rst_n|sdi|sdo|sh_en|start \$I6827
+ VSS DFFL11
* cell instance $54 r0 *1 945.9,1088.9
X$54 clk|done|rst_n|sdi|sdo|sh_en|start clk|done|rst_n|sdi|sdo|sh_en|start
+ clk|done|rst_n|sdi|sdo|sh_en|start clk|done|rst_n|sdi|sdo|sh_en|start \$I6789
+ VSS DFFL11
* cell instance $55 r0 *1 1222.8,1545.2
X$55 clk|done|rst_n|sdi|sdo|sh_en|start clk|done|rst_n|sdi|sdo|sh_en|start
+ \$2701 clk|done|rst_n|sdi|sdo|sh_en|start \$I6832 VSS DFFL11
* cell instance $56 r0 *1 1386.6,1139.6
X$56 \$1718 clk|done|rst_n|sdi|sdo|sh_en|start
+ clk|done|rst_n|sdi|sdo|sh_en|start clk|done|rst_n|sdi|sdo|sh_en|start \$I6814
+ VSS DFFL11
* cell instance $57 r0 *1 1105.8,1494.5
X$57 clk|done|rst_n|sdi|sdo|sh_en|start clk|done|rst_n|sdi|sdo|sh_en|start
+ clk|done|rst_n|sdi|sdo|sh_en|start clk|done|rst_n|sdi|sdo|sh_en|start \$I6833
+ VSS DFFL11
* cell instance $58 r0 *1 1152.6,1545.2
X$58 clk|done|rst_n|sdi|sdo|sh_en|start clk|done|rst_n|sdi|sdo|sh_en|start
+ \$2520 clk|done|rst_n|sdi|sdo|sh_en|start \$I6832 VSS DFFL11
* cell instance $59 r0 *1 665.1,1291.7
X$59 clk|done|rst_n|sdi|sdo|sh_en|start clk|done|rst_n|sdi|sdo|sh_en|start
+ clk|done|rst_n|sdi|sdo|sh_en|start clk|done|rst_n|sdi|sdo|sh_en|start \$I6812
+ VSS DFFL11
* cell instance $60 r0 *1 1308.6,1139.6
X$60 clk|done|rst_n|sdi|sdo|sh_en|start clk|done|rst_n|sdi|sdo|sh_en|start
+ clk|done|rst_n|sdi|sdo|sh_en|start clk|done|rst_n|sdi|sdo|sh_en|start \$I6814
+ VSS DFFL11
* cell instance $61 r0 *1 1074.6,1342.4
X$61 clk|done|rst_n|sdi|sdo|sh_en|start clk|done|rst_n|sdi|sdo|sh_en|start
+ clk|done|rst_n|sdi|sdo|sh_en|start clk|done|rst_n|sdi|sdo|sh_en|start \$I6823
+ VSS DFFL11
* cell instance $62 r0 *1 602.7,1291.7
X$62 clk|done|rst_n|sdi|sdo|sh_en|start clk|done|rst_n|sdi|sdo|sh_en|start
+ clk|done|rst_n|sdi|sdo|sh_en|start clk|done|rst_n|sdi|sdo|sh_en|start \$I6812
+ VSS DFFL11
* cell instance $63 r0 *1 610.5,1139.6
X$63 \$I6814 clk|done|rst_n|sdi|sdo|sh_en|start
+ clk|done|rst_n|sdi|sdo|sh_en|start clk|done|rst_n|sdi|sdo|sh_en|start
+ clk|done|rst_n|sdi|sdo|sh_en|start clk|done|rst_n|sdi|sdo|sh_en|start VSS
+ OAI400
* cell instance $64 r0 *1 1074.6,1494.5
X$64 \$I6833 clk|done|rst_n|sdi|sdo|sh_en|start
+ clk|done|rst_n|sdi|sdo|sh_en|start clk|done|rst_n|sdi|sdo|sh_en|start
+ clk|done|rst_n|sdi|sdo|sh_en|start \$2516 VSS OAI400
* cell instance $65 r0 *1 809.4,1291.7
X$65 \$I6812 clk|done|rst_n|sdi|sdo|sh_en|start \$2061
+ clk|done|rst_n|sdi|sdo|sh_en|start clk|done|rst_n|sdi|sdo|sh_en|start
+ clk|done|rst_n|sdi|sdo|sh_en|start VSS OAI400
* cell instance $66 r0 *1 1449,1443.8
X$66 \$I6819 clk|done|rst_n|sdi|sdo|sh_en|start
+ clk|done|rst_n|sdi|sdo|sh_en|start \$2420 clk|done|rst_n|sdi|sdo|sh_en|start
+ clk|done|rst_n|sdi|sdo|sh_en|start VSS OAI400
* cell instance $67 r0 *1 1152.6,1139.6
X$67 \$I6814 clk|done|rst_n|sdi|sdo|sh_en|start
+ clk|done|rst_n|sdi|sdo|sh_en|start clk|done|rst_n|sdi|sdo|sh_en|start
+ clk|done|rst_n|sdi|sdo|sh_en|start clk|done|rst_n|sdi|sdo|sh_en|start VSS
+ OAI400
* cell instance $68 r0 *1 1530.9,1342.4
X$68 \$I6823 clk|done|rst_n|sdi|sdo|sh_en|start
+ clk|done|rst_n|sdi|sdo|sh_en|start \$2050 clk|done|rst_n|sdi|sdo|sh_en|start
+ \$2220 VSS OAI400
* cell instance $69 r0 *1 1027.8,1190.3
X$69 clk|done|rst_n|sdi|sdo|sh_en|start clk|done|rst_n|sdi|sdo|sh_en|start
+ clk|done|rst_n|sdi|sdo|sh_en|start clk|done|rst_n|sdi|sdo|sh_en|start
+ clk|done|rst_n|sdi|sdo|sh_en|start \$I6808 VSS DFCL11
* cell instance $70 r0 *1 1476.3,1545.2
X$70 clk|done|rst_n|sdi|sdo|sh_en|start clk|done|rst_n|sdi|sdo|sh_en|start
+ clk|done|rst_n|sdi|sdo|sh_en|start clk|done|rst_n|sdi|sdo|sh_en|start
+ clk|done|rst_n|sdi|sdo|sh_en|start \$I6832 VSS DFCL11
* cell instance $71 r0 *1 1456.8,1595.9
X$71 clk|done|rst_n|sdi|sdo|sh_en|start clk|done|rst_n|sdi|sdo|sh_en|start
+ clk|done|rst_n|sdi|sdo|sh_en|start \$2741 clk|done|rst_n|sdi|sdo|sh_en|start
+ \$I6827 VSS DFCL11
* cell instance $72 r0 *1 1324.2,1494.5
X$72 clk|done|rst_n|sdi|sdo|sh_en|start clk|done|rst_n|sdi|sdo|sh_en|start
+ clk|done|rst_n|sdi|sdo|sh_en|start \$2556 clk|done|rst_n|sdi|sdo|sh_en|start
+ \$I6833 VSS DFCL11
* cell instance $73 r0 *1 1406.1,1291.7
X$73 clk|done|rst_n|sdi|sdo|sh_en|start clk|done|rst_n|sdi|sdo|sh_en|start
+ clk|done|rst_n|sdi|sdo|sh_en|start clk|done|rst_n|sdi|sdo|sh_en|start
+ clk|done|rst_n|sdi|sdo|sh_en|start \$I6812 VSS DFCL11
* cell instance $74 r0 *1 1293,1545.2
X$74 clk|done|rst_n|sdi|sdo|sh_en|start clk|done|rst_n|sdi|sdo|sh_en|start
+ clk|done|rst_n|sdi|sdo|sh_en|start \$2694 clk|done|rst_n|sdi|sdo|sh_en|start
+ \$I6832 VSS DFCL11
* cell instance $75 r0 *1 672.9,1393.1
X$75 clk|done|rst_n|sdi|sdo|sh_en|start clk|done|rst_n|sdi|sdo|sh_en|start
+ clk|done|rst_n|sdi|sdo|sh_en|start \$2357 \$I9852 \$I6830 VSS DFCL11
* cell instance $76 r0 *1 669,1494.5
X$76 clk|done|rst_n|sdi|sdo|sh_en|start clk|done|rst_n|sdi|sdo|sh_en|start
+ clk|done|rst_n|sdi|sdo|sh_en|start \$2448 \$I9851 \$I6833 VSS DFCL11
* cell instance $77 r0 *1 641.7,1595.9
X$77 clk|done|rst_n|sdi|sdo|sh_en|start clk|done|rst_n|sdi|sdo|sh_en|start
+ clk|done|rst_n|sdi|sdo|sh_en|start \$2642 \$I9849 \$I6827 VSS DFCL11
* cell instance $78 r0 *1 711.9,1139.6
X$78 clk|done|rst_n|sdi|sdo|sh_en|start clk|done|rst_n|sdi|sdo|sh_en|start
+ clk|done|rst_n|sdi|sdo|sh_en|start clk|done|rst_n|sdi|sdo|sh_en|start \$I9848
+ \$I6814 VSS DFCL11
* cell instance $79 r0 *1 1062.9,1241
X$79 clk|done|rst_n|sdi|sdo|sh_en|start clk|done|rst_n|sdi|sdo|sh_en|start
+ clk|done|rst_n|sdi|sdo|sh_en|start clk|done|rst_n|sdi|sdo|sh_en|start \$I9845
+ \$I6818 VSS DFCL11
* cell instance $80 r0 *1 934.2,1190.3
X$80 clk|done|rst_n|sdi|sdo|sh_en|start clk|done|rst_n|sdi|sdo|sh_en|start
+ clk|done|rst_n|sdi|sdo|sh_en|start \$1849 \$I9844 \$I6808 VSS DFCL11
* cell instance $81 r0 *1 1062.9,1139.6
X$81 clk|done|rst_n|sdi|sdo|sh_en|start clk|done|rst_n|sdi|sdo|sh_en|start
+ clk|done|rst_n|sdi|sdo|sh_en|start \$I6814 VSS OR2100
* cell instance $82 r0 *1 1043.4,1139.6
X$82 clk|done|rst_n|sdi|sdo|sh_en|start clk|done|rst_n|sdi|sdo|sh_en|start
+ clk|done|rst_n|sdi|sdo|sh_en|start \$I6814 VSS OR2100
* cell instance $83 r0 *1 1230.6,1139.6
X$83 clk|done|rst_n|sdi|sdo|sh_en|start clk|done|rst_n|sdi|sdo|sh_en|start
+ clk|done|rst_n|sdi|sdo|sh_en|start \$I6814 VSS OR2100
* cell instance $84 r0 *1 1437.3,1393.1
X$84 clk|done|rst_n|sdi|sdo|sh_en|start clk|done|rst_n|sdi|sdo|sh_en|start
+ clk|done|rst_n|sdi|sdo|sh_en|start \$I6830 VSS OR2100
* cell instance $85 r0 *1 1273.5,1393.1
X$85 clk|done|rst_n|sdi|sdo|sh_en|start clk|done|rst_n|sdi|sdo|sh_en|start
+ clk|done|rst_n|sdi|sdo|sh_en|start \$I6830 VSS OR2100
* cell instance $86 r0 *1 828.9,1088.9
X$86 clk|done|rst_n|sdi|sdo|sh_en|start clk|done|rst_n|sdi|sdo|sh_en|start
+ \$1636 \$I6789 VSS OR2100
* cell instance $87 r0 *1 1129.2,683.3
X$87 clk|done|rst_n|sdi|sdo|sh_en|start clk|done|rst_n|sdi|sdo|sh_en|start
+ \$778 \$I6788 VSS OR2100
* cell instance $88 r0 *1 891.3,1291.7
X$88 clk|done|rst_n|sdi|sdo|sh_en|start clk|done|rst_n|sdi|sdo|sh_en|start
+ clk|done|rst_n|sdi|sdo|sh_en|start \$I6812 VSS OR2100
* cell instance $89 r0 *1 1378.8,1443.8
X$89 clk|done|rst_n|sdi|sdo|sh_en|start clk|done|rst_n|sdi|sdo|sh_en|start
+ clk|done|rst_n|sdi|sdo|sh_en|start \$I6819 VSS OR2100
* cell instance $90 r0 *1 821.1,1190.3
X$90 clk|done|rst_n|sdi|sdo|sh_en|start clk|done|rst_n|sdi|sdo|sh_en|start
+ clk|done|rst_n|sdi|sdo|sh_en|start \$I6808 VSS OR2100
* cell instance $91 r0 *1 727.5,1291.7
X$91 clk|done|rst_n|sdi|sdo|sh_en|start clk|done|rst_n|sdi|sdo|sh_en|start
+ clk|done|rst_n|sdi|sdo|sh_en|start \$I6812 VSS OR2100
* cell instance $92 r0 *1 1113.6,1190.3
X$92 clk|done|rst_n|sdi|sdo|sh_en|start clk|done|rst_n|sdi|sdo|sh_en|start
+ clk|done|rst_n|sdi|sdo|sh_en|start \$I6808 VSS OR2100
* cell instance $93 r0 *1 774.3,1190.3
X$93 clk|done|rst_n|sdi|sdo|sh_en|start clk|done|rst_n|sdi|sdo|sh_en|start
+ clk|done|rst_n|sdi|sdo|sh_en|start \$I6808 VSS OR2100
* cell instance $94 r0 *1 977.1,1595.9
X$94 clk|done|rst_n|sdi|sdo|sh_en|start clk|done|rst_n|sdi|sdo|sh_en|start
+ clk|done|rst_n|sdi|sdo|sh_en|start \$I6827 VSS OR2100
* cell instance $95 r0 *1 1363.2,886.1
X$95 clk|done|rst_n|sdi|sdo|sh_en|start clk|done|rst_n|sdi|sdo|sh_en|start
+ clk|done|rst_n|sdi|sdo|sh_en|start \$I6796 VSS OR2100
* cell instance $96 r0 *1 591,1393.1
X$96 clk|done|rst_n|sdi|sdo|sh_en|start clk|done|rst_n|sdi|sdo|sh_en|start
+ clk|done|rst_n|sdi|sdo|sh_en|start \$I6830 VSS OR2100
* cell instance $97 r0 *1 645.6,1088.9
X$97 clk|done|rst_n|sdi|sdo|sh_en|start clk|done|rst_n|sdi|sdo|sh_en|start
+ clk|done|rst_n|sdi|sdo|sh_en|start \$I6789 VSS OR2100
* cell instance $98 r0 *1 1285.2,1038.2
X$98 clk|done|rst_n|sdi|sdo|sh_en|start clk|done|rst_n|sdi|sdo|sh_en|start
+ clk|done|rst_n|sdi|sdo|sh_en|start \$I6775 VSS OR2100
* cell instance $99 r0 *1 817.2,886.1
X$99 \$1157 clk|done|rst_n|sdi|sdo|sh_en|start
+ clk|done|rst_n|sdi|sdo|sh_en|start \$I6796 VSS OR2100
* cell instance $100 r0 *1 828.9,1545.2
X$100 \$2539 clk|done|rst_n|sdi|sdo|sh_en|start
+ clk|done|rst_n|sdi|sdo|sh_en|start \$I6832 VSS OR2100
* cell instance $101 r0 *1 840.6,1595.9
X$101 \$2647 clk|done|rst_n|sdi|sdo|sh_en|start
+ clk|done|rst_n|sdi|sdo|sh_en|start \$I6827 VSS OR2100
* cell instance $102 r0 *1 1304.7,632.6
X$102 \$585 clk|done|rst_n|sdi|sdo|sh_en|start
+ clk|done|rst_n|sdi|sdo|sh_en|start \$I6781 VSS OR2100
* cell instance $103 r0 *1 1281.3,835.4
X$103 clk|done|rst_n|sdi|sdo|sh_en|start \$1082
+ clk|done|rst_n|sdi|sdo|sh_en|start \$1084 clk|done|rst_n|sdi|sdo|sh_en|start
+ \$I6760 VSS NOR400
* cell instance $104 r0 *1 992.7,1139.6
X$104 clk|done|rst_n|sdi|sdo|sh_en|start clk|done|rst_n|sdi|sdo|sh_en|start
+ clk|done|rst_n|sdi|sdo|sh_en|start clk|done|rst_n|sdi|sdo|sh_en|start
+ clk|done|rst_n|sdi|sdo|sh_en|start \$I6814 VSS NOR400
* cell instance $105 r0 *1 1363.2,1393.1
X$105 clk|done|rst_n|sdi|sdo|sh_en|start clk|done|rst_n|sdi|sdo|sh_en|start
+ clk|done|rst_n|sdi|sdo|sh_en|start clk|done|rst_n|sdi|sdo|sh_en|start
+ clk|done|rst_n|sdi|sdo|sh_en|start \$I6830 VSS NOR400
* cell instance $106 r0 *1 1499.7,1443.8
X$106 clk|done|rst_n|sdi|sdo|sh_en|start \$2349
+ clk|done|rst_n|sdi|sdo|sh_en|start clk|done|rst_n|sdi|sdo|sh_en|start
+ clk|done|rst_n|sdi|sdo|sh_en|start \$I6819 VSS NOR400
* cell instance $107 r0 *1 1234.5,632.6
X$107 \$I6781 clk|done|rst_n|sdi|sdo|sh_en|start
+ clk|done|rst_n|sdi|sdo|sh_en|start \$688 \$641 VSS OR3100
* cell instance $108 r0 *1 571.5,1139.6
X$108 \$I6814 clk|done|rst_n|sdi|sdo|sh_en|start
+ clk|done|rst_n|sdi|sdo|sh_en|start clk|done|rst_n|sdi|sdo|sh_en|start
+ clk|done|rst_n|sdi|sdo|sh_en|start VSS OR3100
* cell instance $109 r0 *1 871.8,1088.9
X$109 \$I6789 clk|done|rst_n|sdi|sdo|sh_en|start
+ clk|done|rst_n|sdi|sdo|sh_en|start clk|done|rst_n|sdi|sdo|sh_en|start
+ clk|done|rst_n|sdi|sdo|sh_en|start VSS OR3100
* cell instance $110 r0 *1 864,1190.3
X$110 \$I6808 clk|done|rst_n|sdi|sdo|sh_en|start
+ clk|done|rst_n|sdi|sdo|sh_en|start \$1848 clk|done|rst_n|sdi|sdo|sh_en|start
+ VSS OR3100
* cell instance $111 r0 *1 1179.9,1139.6
X$111 \$I6814 clk|done|rst_n|sdi|sdo|sh_en|start
+ clk|done|rst_n|sdi|sdo|sh_en|start clk|done|rst_n|sdi|sdo|sh_en|start
+ clk|done|rst_n|sdi|sdo|sh_en|start VSS OR3100
* cell instance $112 r0 *1 1296.9,1443.8
X$112 \$I6819 clk|done|rst_n|sdi|sdo|sh_en|start
+ clk|done|rst_n|sdi|sdo|sh_en|start clk|done|rst_n|sdi|sdo|sh_en|start
+ clk|done|rst_n|sdi|sdo|sh_en|start VSS NOR300
* cell instance $113 r0 *1 1320.3,1443.8
X$113 \$I6819 clk|done|rst_n|sdi|sdo|sh_en|start
+ clk|done|rst_n|sdi|sdo|sh_en|start clk|done|rst_n|sdi|sdo|sh_en|start
+ clk|done|rst_n|sdi|sdo|sh_en|start VSS NOR300
* cell instance $114 r0 *1 548.1,1139.6
X$114 \$I6814 clk|done|rst_n|sdi|sdo|sh_en|start
+ clk|done|rst_n|sdi|sdo|sh_en|start clk|done|rst_n|sdi|sdo|sh_en|start
+ clk|done|rst_n|sdi|sdo|sh_en|start VSS NOR300
* cell instance $115 r0 *1 848.4,1241
X$115 \$I6818 clk|done|rst_n|sdi|sdo|sh_en|start
+ clk|done|rst_n|sdi|sdo|sh_en|start clk|done|rst_n|sdi|sdo|sh_en|start \$1848
+ VSS NOR300
* cell instance $116 r0 *1 1273.5,1494.5
X$116 \$I6833 clk|done|rst_n|sdi|sdo|sh_en|start
+ clk|done|rst_n|sdi|sdo|sh_en|start clk|done|rst_n|sdi|sdo|sh_en|start
+ clk|done|rst_n|sdi|sdo|sh_en|start VSS NOR300
* cell instance $117 r0 *1 1289.1,1342.4
X$117 \$I6823 clk|done|rst_n|sdi|sdo|sh_en|start
+ clk|done|rst_n|sdi|sdo|sh_en|start clk|done|rst_n|sdi|sdo|sh_en|start
+ clk|done|rst_n|sdi|sdo|sh_en|start VSS NOR300
* cell instance $118 r0 *1 567.6,1190.3
X$118 \$I6808 clk|done|rst_n|sdi|sdo|sh_en|start
+ clk|done|rst_n|sdi|sdo|sh_en|start clk|done|rst_n|sdi|sdo|sh_en|start
+ clk|done|rst_n|sdi|sdo|sh_en|start VSS NOR300
* cell instance $119 r0 *1 1195.5,1088.9
X$119 \$I6789 clk|done|rst_n|sdi|sdo|sh_en|start
+ clk|done|rst_n|sdi|sdo|sh_en|start clk|done|rst_n|sdi|sdo|sh_en|start
+ clk|done|rst_n|sdi|sdo|sh_en|start VSS NOR300
* cell instance $120 r0 *1 1324.2,1393.1
X$120 \$I6830 clk|done|rst_n|sdi|sdo|sh_en|start
+ clk|done|rst_n|sdi|sdo|sh_en|start clk|done|rst_n|sdi|sdo|sh_en|start
+ clk|done|rst_n|sdi|sdo|sh_en|start VSS NOR300
* cell instance $121 r0 *1 1300.8,1494.5
X$121 \$I6833 clk|done|rst_n|sdi|sdo|sh_en|start \$2556
+ clk|done|rst_n|sdi|sdo|sh_en|start clk|done|rst_n|sdi|sdo|sh_en|start VSS
+ NOR300
* cell instance $122 r0 *1 1339.8,886.1
X$122 \$I6796 clk|done|rst_n|sdi|sdo|sh_en|start
+ clk|done|rst_n|sdi|sdo|sh_en|start clk|done|rst_n|sdi|sdo|sh_en|start VSS
+ AND200
* cell instance $123 r0 *1 1421.7,1545.2
X$123 \$I6832 clk|done|rst_n|sdi|sdo|sh_en|start
+ clk|done|rst_n|sdi|sdo|sh_en|start clk|done|rst_n|sdi|sdo|sh_en|start VSS
+ AND200
* cell instance $124 r0 *1 1016.1,1494.5
X$124 \$I6833 clk|done|rst_n|sdi|sdo|sh_en|start
+ clk|done|rst_n|sdi|sdo|sh_en|start clk|done|rst_n|sdi|sdo|sh_en|start VSS
+ AND200
* cell instance $125 r0 *1 1250.1,1342.4
X$125 \$I6823 clk|done|rst_n|sdi|sdo|sh_en|start
+ clk|done|rst_n|sdi|sdo|sh_en|start clk|done|rst_n|sdi|sdo|sh_en|start VSS
+ AND200
* cell instance $126 r0 *1 1133.1,886.1
X$126 \$I6796 clk|done|rst_n|sdi|sdo|sh_en|start
+ clk|done|rst_n|sdi|sdo|sh_en|start clk|done|rst_n|sdi|sdo|sh_en|start VSS
+ AND200
* cell instance $127 r0 *1 555.9,1342.4
X$127 \$I6823 clk|done|rst_n|sdi|sdo|sh_en|start
+ clk|done|rst_n|sdi|sdo|sh_en|start clk|done|rst_n|sdi|sdo|sh_en|start VSS
+ AND200
* cell instance $128 r0 *1 953.7,1038.2
X$128 \$I6775 clk|done|rst_n|sdi|sdo|sh_en|start
+ clk|done|rst_n|sdi|sdo|sh_en|start clk|done|rst_n|sdi|sdo|sh_en|start VSS
+ AND200
* cell instance $129 r0 *1 1410,1494.5
X$129 \$I6833 clk|done|rst_n|sdi|sdo|sh_en|start
+ clk|done|rst_n|sdi|sdo|sh_en|start clk|done|rst_n|sdi|sdo|sh_en|start VSS
+ AND200
* cell instance $130 r0 *1 1222.8,1443.8
X$130 \$I6819 clk|done|rst_n|sdi|sdo|sh_en|start
+ clk|done|rst_n|sdi|sdo|sh_en|start clk|done|rst_n|sdi|sdo|sh_en|start VSS
+ AND200
* cell instance $131 r0 *1 1569.9,1291.7
X$131 \$I6812 clk|done|rst_n|sdi|sdo|sh_en|start
+ clk|done|rst_n|sdi|sdo|sh_en|start \$2053 VSS AND200
* cell instance $132 r0 *1 1187.7,936.8
X$132 \$I6730 clk|done|rst_n|sdi|sdo|sh_en|start
+ clk|done|rst_n|sdi|sdo|sh_en|start clk|done|rst_n|sdi|sdo|sh_en|start VSS
+ AND200
* cell instance $133 r0 *1 1554.3,1088.9
X$133 \$I6789 clk|done|rst_n|sdi|sdo|sh_en|start
+ clk|done|rst_n|sdi|sdo|sh_en|start clk|done|rst_n|sdi|sdo|sh_en|start VSS
+ AND200
* cell instance $134 r0 *1 1261.8,632.6
X$134 \$I6781 clk|done|rst_n|sdi|sdo|sh_en|start
+ clk|done|rst_n|sdi|sdo|sh_en|start clk|done|rst_n|sdi|sdo|sh_en|start VSS
+ AND200
* cell instance $135 r0 *1 1335.9,1291.7
X$135 \$I6812 clk|done|rst_n|sdi|sdo|sh_en|start
+ clk|done|rst_n|sdi|sdo|sh_en|start clk|done|rst_n|sdi|sdo|sh_en|start VSS
+ AND200
* cell instance $136 r0 *1 1250.1,1088.9
X$136 \$I6789 clk|done|rst_n|sdi|sdo|sh_en|start
+ clk|done|rst_n|sdi|sdo|sh_en|start clk|done|rst_n|sdi|sdo|sh_en|start VSS
+ AND200
* cell instance $137 r0 *1 953.7,987.5
X$137 \$I6725 clk|done|rst_n|sdi|sdo|sh_en|start
+ clk|done|rst_n|sdi|sdo|sh_en|start clk|done|rst_n|sdi|sdo|sh_en|start VSS
+ AND200
* cell instance $138 r0 *1 1211.1,632.6
X$138 \$I6781 \$688 clk|done|rst_n|sdi|sdo|sh_en|start
+ clk|done|rst_n|sdi|sdo|sh_en|start VSS AND200
* cell instance $139 r0 *1 727.5,1241
X$139 \$I6818 clk|done|rst_n|sdi|sdo|sh_en|start
+ clk|done|rst_n|sdi|sdo|sh_en|start clk|done|rst_n|sdi|sdo|sh_en|start
+ clk|done|rst_n|sdi|sdo|sh_en|start VSS NND300
* cell instance $140 r0 *1 614.4,1342.4
X$140 \$I6823 clk|done|rst_n|sdi|sdo|sh_en|start
+ clk|done|rst_n|sdi|sdo|sh_en|start clk|done|rst_n|sdi|sdo|sh_en|start
+ clk|done|rst_n|sdi|sdo|sh_en|start VSS NND300
* cell instance $141 r0 *1 1589.4,1139.6
X$141 \$I6814 clk|done|rst_n|sdi|sdo|sh_en|start
+ clk|done|rst_n|sdi|sdo|sh_en|start clk|done|rst_n|sdi|sdo|sh_en|start
+ clk|done|rst_n|sdi|sdo|sh_en|start VSS NND300
* cell instance $142 r0 *1 836.7,886.1
X$142 \$I6796 clk|done|rst_n|sdi|sdo|sh_en|start \$1157
+ clk|done|rst_n|sdi|sdo|sh_en|start clk|done|rst_n|sdi|sdo|sh_en|start VSS
+ NND300
* cell instance $143 r0 *1 875.7,1241
X$143 \$I6818 clk|done|rst_n|sdi|sdo|sh_en|start
+ clk|done|rst_n|sdi|sdo|sh_en|start clk|done|rst_n|sdi|sdo|sh_en|start
+ clk|done|rst_n|sdi|sdo|sh_en|start VSS NND300
* cell instance $144 r0 *1 1281.3,1139.6
X$144 \$I6814 clk|done|rst_n|sdi|sdo|sh_en|start \$1715
+ clk|done|rst_n|sdi|sdo|sh_en|start clk|done|rst_n|sdi|sdo|sh_en|start VSS
+ NND300
* cell instance $145 r0 *1 793.8,835.4
X$145 \$I6760 clk|done|rst_n|sdi|sdo|sh_en|start
+ clk|done|rst_n|sdi|sdo|sh_en|start clk|done|rst_n|sdi|sdo|sh_en|start
+ clk|done|rst_n|sdi|sdo|sh_en|start VSS NND300
* cell instance $146 r0 *1 1250.1,1494.5
X$146 \$I6833 clk|done|rst_n|sdi|sdo|sh_en|start
+ clk|done|rst_n|sdi|sdo|sh_en|start clk|done|rst_n|sdi|sdo|sh_en|start
+ clk|done|rst_n|sdi|sdo|sh_en|start VSS NND300
* cell instance $147 r0 *1 700.2,1190.3
X$147 \$I6808 clk|done|rst_n|sdi|sdo|sh_en|start
+ clk|done|rst_n|sdi|sdo|sh_en|start clk|done|rst_n|sdi|sdo|sh_en|start
+ clk|done|rst_n|sdi|sdo|sh_en|start VSS NND300
* cell instance $148 r0 *1 1382.7,1291.7
X$148 \$I6812 clk|done|rst_n|sdi|sdo|sh_en|start
+ clk|done|rst_n|sdi|sdo|sh_en|start clk|done|rst_n|sdi|sdo|sh_en|start
+ clk|done|rst_n|sdi|sdo|sh_en|start VSS NND300
* cell instance $149 r0 *1 867.9,1291.7
X$149 \$I6812 clk|done|rst_n|sdi|sdo|sh_en|start
+ clk|done|rst_n|sdi|sdo|sh_en|start clk|done|rst_n|sdi|sdo|sh_en|start
+ clk|done|rst_n|sdi|sdo|sh_en|start VSS NND300
* cell instance $150 r0 *1 1312.5,1342.4
X$150 \$I6823 clk|done|rst_n|sdi|sdo|sh_en|start
+ clk|done|rst_n|sdi|sdo|sh_en|start clk|done|rst_n|sdi|sdo|sh_en|start
+ clk|done|rst_n|sdi|sdo|sh_en|start VSS NND300
* cell instance $151 r0 *1 903,987.5
X$151 \$I6725 clk|done|rst_n|sdi|sdo|sh_en|start
+ clk|done|rst_n|sdi|sdo|sh_en|start clk|done|rst_n|sdi|sdo|sh_en|start
+ clk|done|rst_n|sdi|sdo|sh_en|start VSS NND300
* cell instance $152 r0 *1 984.9,683.3
X$152 \$I6788 clk|done|rst_n|sdi|sdo|sh_en|start \$771
+ clk|done|rst_n|sdi|sdo|sh_en|start clk|done|rst_n|sdi|sdo|sh_en|start VSS
+ NND300
* cell instance $153 r0 *1 1585.5,1038.2
X$153 \$I6775 clk|done|rst_n|sdi|sdo|sh_en|start
+ clk|done|rst_n|sdi|sdo|sh_en|start clk|done|rst_n|sdi|sdo|sh_en|start
+ clk|done|rst_n|sdi|sdo|sh_en|start VSS NND300
* cell instance $154 r0 *1 1281.3,581.9
X$154 \$I2828 clk|done|rst_n|sdi|sdo|sh_en|start \$578 \$508
+ clk|done|rst_n|sdi|sdo|sh_en|start VSS NND300
* cell instance $155 r0 *1 622.2,1241
X$155 \$I6818 clk|done|rst_n|sdi|sdo|sh_en|start
+ clk|done|rst_n|sdi|sdo|sh_en|start \$1923 clk|done|rst_n|sdi|sdo|sh_en|start
+ VSS NND300
* cell instance $156 r0 *1 587.1,1241
X$156 \$I6818 clk|done|rst_n|sdi|sdo|sh_en|start
+ clk|done|rst_n|sdi|sdo|sh_en|start \$1921 clk|done|rst_n|sdi|sdo|sh_en|start
+ VSS NND300
* cell instance $157 r0 *1 1530.9,1291.7
X$157 \$I6812 clk|done|rst_n|sdi|sdo|sh_en|start \$2050 \$2052
+ clk|done|rst_n|sdi|sdo|sh_en|start VSS NND300
* cell instance $158 r0 *1 981,1443.8
X$158 \$I6819 clk|done|rst_n|sdi|sdo|sh_en|start
+ clk|done|rst_n|sdi|sdo|sh_en|start \$2279 clk|done|rst_n|sdi|sdo|sh_en|start
+ VSS NND300
* cell instance $159 r0 *1 957.6,1443.8
X$159 \$I6819 clk|done|rst_n|sdi|sdo|sh_en|start
+ clk|done|rst_n|sdi|sdo|sh_en|start \$2277 clk|done|rst_n|sdi|sdo|sh_en|start
+ VSS NND300
* cell instance $160 r0 *1 1105.8,683.3
X$160 \$I6788 clk|done|rst_n|sdi|sdo|sh_en|start
+ clk|done|rst_n|sdi|sdo|sh_en|start \$778 clk|done|rst_n|sdi|sdo|sh_en|start
+ VSS NND300
* cell instance $161 r0 *1 883.5,632.6
X$161 \$I6781 clk|done|rst_n|sdi|sdo|sh_en|start
+ clk|done|rst_n|sdi|sdo|sh_en|start \$672 clk|done|rst_n|sdi|sdo|sh_en|start
+ VSS NND300
* cell instance $162 r0 *1 1589.4,1190.3
X$162 \$I6808 clk|done|rst_n|sdi|sdo|sh_en|start
+ clk|done|rst_n|sdi|sdo|sh_en|start \$1865 clk|done|rst_n|sdi|sdo|sh_en|start
+ VSS NND300
* cell instance $163 r0 *1 1530.9,1393.1
X$163 clk|done|rst_n|sdi|sdo|sh_en|start clk|done|rst_n|sdi|sdo|sh_en|start
+ \$I6830 clk|done|rst_n|sdi|sdo|sh_en|start clk|done|rst_n|sdi|sdo|sh_en|start
+ VSS ADNR00
* cell instance $164 r0 *1 641.7,683.3
X$164 clk|done|rst_n|sdi|sdo|sh_en|start clk|done|rst_n|sdi|sdo|sh_en|start
+ \$I6788 clk|done|rst_n|sdi|sdo|sh_en|start clk|done|rst_n|sdi|sdo|sh_en|start
+ VSS ADNR00
* cell instance $165 r0 *1 1144.8,1393.1
X$165 clk|done|rst_n|sdi|sdo|sh_en|start clk|done|rst_n|sdi|sdo|sh_en|start
+ \$I6830 clk|done|rst_n|sdi|sdo|sh_en|start \$2284 VSS ADNR00
* cell instance $166 r0 *1 1137,1342.4
X$166 clk|done|rst_n|sdi|sdo|sh_en|start clk|done|rst_n|sdi|sdo|sh_en|start
+ \$I6823 clk|done|rst_n|sdi|sdo|sh_en|start \$2074 VSS ADNR00
* cell instance $167 r0 *1 618.3,1088.9
X$167 clk|done|rst_n|sdi|sdo|sh_en|start clk|done|rst_n|sdi|sdo|sh_en|start
+ \$I6789 \$1456 clk|done|rst_n|sdi|sdo|sh_en|start VSS ADNR00
* cell instance $168 r0 *1 1328.1,1190.3
X$168 clk|done|rst_n|sdi|sdo|sh_en|start clk|done|rst_n|sdi|sdo|sh_en|start
+ \$I6808 \$1715 clk|done|rst_n|sdi|sdo|sh_en|start VSS ADNR00
* cell instance $169 r0 *1 1316.4,581.9
X$169 clk|done|rst_n|sdi|sdo|sh_en|start clk|done|rst_n|sdi|sdo|sh_en|start
+ \$I2828 clk|done|rst_n|sdi|sdo|sh_en|start \$585 VSS ADNR00
* cell instance $170 r0 *1 961.5,581.9
X$170 clk|done|rst_n|sdi|sdo|sh_en|start \$563 \$I2828
+ clk|done|rst_n|sdi|sdo|sh_en|start clk|done|rst_n|sdi|sdo|sh_en|start VSS
+ ADNR00
* cell instance $171 r0 *1 1456.8,1088.9
X$171 clk|done|rst_n|sdi|sdo|sh_en|start clk|done|rst_n|sdi|sdo|sh_en|start
+ \$I6789 clk|done|rst_n|sdi|sdo|sh_en|start \$1657 VSS ADNR00
* cell instance $172 r0 *1 1343.7,936.8
X$172 clk|done|rst_n|sdi|sdo|sh_en|start clk|done|rst_n|sdi|sdo|sh_en|start
+ \$I6730 clk|done|rst_n|sdi|sdo|sh_en|start clk|done|rst_n|sdi|sdo|sh_en|start
+ VSS ADNR00
* cell instance $173 r0 *1 1105.8,1088.9
X$173 clk|done|rst_n|sdi|sdo|sh_en|start clk|done|rst_n|sdi|sdo|sh_en|start
+ \$I6789 clk|done|rst_n|sdi|sdo|sh_en|start \$1645 VSS ADNR00
* cell instance $174 r0 *1 1363.2,1038.2
X$174 clk|done|rst_n|sdi|sdo|sh_en|start clk|done|rst_n|sdi|sdo|sh_en|start
+ \$I6775 clk|done|rst_n|sdi|sdo|sh_en|start clk|done|rst_n|sdi|sdo|sh_en|start
+ VSS ADNR00
* cell instance $175 r0 *1 637.8,1139.6
X$175 clk|done|rst_n|sdi|sdo|sh_en|start clk|done|rst_n|sdi|sdo|sh_en|start
+ \$I6814 clk|done|rst_n|sdi|sdo|sh_en|start clk|done|rst_n|sdi|sdo|sh_en|start
+ VSS ADNR00
* cell instance $176 r0 *1 501.3,734
X$176 clk|done|rst_n|sdi|sdo|sh_en|start clk|done|rst_n|sdi|sdo|sh_en|start
+ \$I2783 clk|done|rst_n|sdi|sdo|sh_en|start clk|done|rst_n|sdi|sdo|sh_en|start
+ VSS ADNR00
* cell instance $177 r0 *1 1215,936.8
X$177 clk|done|rst_n|sdi|sdo|sh_en|start clk|done|rst_n|sdi|sdo|sh_en|start
+ \$I6730 clk|done|rst_n|sdi|sdo|sh_en|start clk|done|rst_n|sdi|sdo|sh_en|start
+ VSS ADNR00
* cell instance $178 r0 *1 1300.8,936.8
X$178 clk|done|rst_n|sdi|sdo|sh_en|start clk|done|rst_n|sdi|sdo|sh_en|start
+ \$I6730 clk|done|rst_n|sdi|sdo|sh_en|start \$1307 VSS ADNR00
* cell instance $179 r0 *1 1199.4,1241
X$179 clk|done|rst_n|sdi|sdo|sh_en|start \$1857 \$I6818 \$1905
+ clk|done|rst_n|sdi|sdo|sh_en|start VSS ADNR00
* cell instance $180 r0 *1 1140.9,936.8
X$180 clk|done|rst_n|sdi|sdo|sh_en|start clk|done|rst_n|sdi|sdo|sh_en|start
+ \$I6730 clk|done|rst_n|sdi|sdo|sh_en|start clk|done|rst_n|sdi|sdo|sh_en|start
+ VSS ADNR00
* cell instance $181 r0 *1 1296.9,1241
X$181 clk|done|rst_n|sdi|sdo|sh_en|start clk|done|rst_n|sdi|sdo|sh_en|start
+ \$I6818 clk|done|rst_n|sdi|sdo|sh_en|start clk|done|rst_n|sdi|sdo|sh_en|start
+ VSS ADNR00
* cell instance $182 r0 *1 801.6,632.6
X$182 \$641 clk|done|rst_n|sdi|sdo|sh_en|start \$I6781
+ clk|done|rst_n|sdi|sdo|sh_en|start clk|done|rst_n|sdi|sdo|sh_en|start VSS
+ ADNR00
* cell instance $183 r0 *1 903,1139.6
X$183 \$1639 clk|done|rst_n|sdi|sdo|sh_en|start \$I6814
+ clk|done|rst_n|sdi|sdo|sh_en|start clk|done|rst_n|sdi|sdo|sh_en|start VSS
+ ADNR00
* cell instance $184 r0 *1 805.5,1139.6
X$184 \$1636 clk|done|rst_n|sdi|sdo|sh_en|start \$I6814 \$1675
+ clk|done|rst_n|sdi|sdo|sh_en|start VSS ADNR00
* cell instance $185 r0 *1 793.8,1190.3
X$185 \$1675 clk|done|rst_n|sdi|sdo|sh_en|start \$I6808
+ clk|done|rst_n|sdi|sdo|sh_en|start clk|done|rst_n|sdi|sdo|sh_en|start VSS
+ ADNR00
* cell instance $186 r0 *1 1211.1,1494.5
X$186 \$2520 clk|done|rst_n|sdi|sdo|sh_en|start \$I6833
+ clk|done|rst_n|sdi|sdo|sh_en|start clk|done|rst_n|sdi|sdo|sh_en|start VSS
+ ADNR00
* cell instance $187 r0 *1 1616.7,1241
X$187 \$1949 clk|done|rst_n|sdi|sdo|sh_en|start \$I6818 \$1865
+ clk|done|rst_n|sdi|sdo|sh_en|start VSS ADNR00
* cell instance $188 r0 *1 1616.7,1139.6
X$188 \$1724 \$1723 \$I6814 clk|done|rst_n|sdi|sdo|sh_en|start
+ clk|done|rst_n|sdi|sdo|sh_en|start VSS ADNR00
* cell instance $189 r0 *1 1386.6,1241
X$189 \$1861 clk|done|rst_n|sdi|sdo|sh_en|start \$I6818
+ clk|done|rst_n|sdi|sdo|sh_en|start clk|done|rst_n|sdi|sdo|sh_en|start VSS
+ ADNR00
* cell instance $190 r0 *1 700.2,1443.8
X$190 \$2357 clk|done|rst_n|sdi|sdo|sh_en|start \$I6819
+ clk|done|rst_n|sdi|sdo|sh_en|start clk|done|rst_n|sdi|sdo|sh_en|start VSS
+ ADNR00
* cell instance $191 r0 *1 1612.8,1038.2
X$191 \$1534 clk|done|rst_n|sdi|sdo|sh_en|start \$I6775
+ clk|done|rst_n|sdi|sdo|sh_en|start clk|done|rst_n|sdi|sdo|sh_en|start VSS
+ ADNR00
* cell instance $192 r0 *1 1234.5,1595.9
X$192 \$2701 clk|done|rst_n|sdi|sdo|sh_en|start \$I6827
+ clk|done|rst_n|sdi|sdo|sh_en|start \$2735 VSS ADNR00
* cell instance $193 r0 *1 1378.8,1545.2
X$193 clk|done|rst_n|sdi|sdo|sh_en|start clk|done|rst_n|sdi|sdo|sh_en|start
+ clk|done|rst_n|sdi|sdo|sh_en|start \$I6832 VSS XNR200
* cell instance $194 r0 *1 778.2,1393.1
X$194 clk|done|rst_n|sdi|sdo|sh_en|start clk|done|rst_n|sdi|sdo|sh_en|start
+ clk|done|rst_n|sdi|sdo|sh_en|start \$I6830 VSS XNR200
* cell instance $195 r0 *1 1546.5,1190.3
X$195 clk|done|rst_n|sdi|sdo|sh_en|start clk|done|rst_n|sdi|sdo|sh_en|start
+ clk|done|rst_n|sdi|sdo|sh_en|start \$I6808 VSS XNR200
* cell instance $196 r0 *1 864,1342.4
X$196 clk|done|rst_n|sdi|sdo|sh_en|start clk|done|rst_n|sdi|sdo|sh_en|start
+ clk|done|rst_n|sdi|sdo|sh_en|start \$I6823 VSS XNR200
* cell instance $197 r0 *1 860.1,987.5
X$197 clk|done|rst_n|sdi|sdo|sh_en|start clk|done|rst_n|sdi|sdo|sh_en|start
+ clk|done|rst_n|sdi|sdo|sh_en|start \$I6725 VSS XNR200
* cell instance $198 r0 *1 754.8,1342.4
X$198 clk|done|rst_n|sdi|sdo|sh_en|start clk|done|rst_n|sdi|sdo|sh_en|start
+ clk|done|rst_n|sdi|sdo|sh_en|start \$I6823 VSS XNR200
* cell instance $199 r0 *1 711.9,1342.4
X$199 clk|done|rst_n|sdi|sdo|sh_en|start clk|done|rst_n|sdi|sdo|sh_en|start
+ clk|done|rst_n|sdi|sdo|sh_en|start \$I6823 VSS XNR200
* cell instance $200 r0 *1 926.4,1393.1
X$200 clk|done|rst_n|sdi|sdo|sh_en|start clk|done|rst_n|sdi|sdo|sh_en|start
+ clk|done|rst_n|sdi|sdo|sh_en|start \$I6830 VSS XNR200
* cell instance $201 r0 *1 860.1,1139.6
X$201 clk|done|rst_n|sdi|sdo|sh_en|start clk|done|rst_n|sdi|sdo|sh_en|start
+ \$1675 \$I6814 VSS XNR200
* cell instance $202 r0 *1 906.9,1494.5
X$202 clk|done|rst_n|sdi|sdo|sh_en|start clk|done|rst_n|sdi|sdo|sh_en|start
+ \$2364 \$I6833 VSS XNR200
* cell instance $203 r0 *1 1187.7,1342.4
X$203 \$I6823 clk|done|rst_n|sdi|sdo|sh_en|start
+ clk|done|rst_n|sdi|sdo|sh_en|start clk|done|rst_n|sdi|sdo|sh_en|start
+ clk|done|rst_n|sdi|sdo|sh_en|start clk|done|rst_n|sdi|sdo|sh_en|start VSS
+ NND400
* cell instance $204 r0 *1 1390.5,886.1
X$204 \$I6796 clk|done|rst_n|sdi|sdo|sh_en|start
+ clk|done|rst_n|sdi|sdo|sh_en|start clk|done|rst_n|sdi|sdo|sh_en|start
+ clk|done|rst_n|sdi|sdo|sh_en|start clk|done|rst_n|sdi|sdo|sh_en|start VSS
+ NND400
* cell instance $205 r0 *1 1534.8,835.4
X$205 \$I6760 clk|done|rst_n|sdi|sdo|sh_en|start \$1087
+ clk|done|rst_n|sdi|sdo|sh_en|start clk|done|rst_n|sdi|sdo|sh_en|start
+ clk|done|rst_n|sdi|sdo|sh_en|start VSS NND400
* cell instance $206 r0 *1 1098,987.5
X$206 \$I6725 clk|done|rst_n|sdi|sdo|sh_en|start
+ clk|done|rst_n|sdi|sdo|sh_en|start clk|done|rst_n|sdi|sdo|sh_en|start
+ clk|done|rst_n|sdi|sdo|sh_en|start clk|done|rst_n|sdi|sdo|sh_en|start VSS
+ NND400
* cell instance $207 r0 *1 903,835.4
X$207 \$I6760 clk|done|rst_n|sdi|sdo|sh_en|start
+ clk|done|rst_n|sdi|sdo|sh_en|start clk|done|rst_n|sdi|sdo|sh_en|start
+ clk|done|rst_n|sdi|sdo|sh_en|start clk|done|rst_n|sdi|sdo|sh_en|start VSS
+ NND400
* cell instance $208 r0 *1 1261.8,1291.7
X$208 \$I6812 clk|done|rst_n|sdi|sdo|sh_en|start
+ clk|done|rst_n|sdi|sdo|sh_en|start \$2042 clk|done|rst_n|sdi|sdo|sh_en|start
+ clk|done|rst_n|sdi|sdo|sh_en|start VSS NND400
* cell instance $209 r0 *1 906.9,1342.4
X$209 \$I6823 clk|done|rst_n|sdi|sdo|sh_en|start \$2139
+ clk|done|rst_n|sdi|sdo|sh_en|start clk|done|rst_n|sdi|sdo|sh_en|start
+ clk|done|rst_n|sdi|sdo|sh_en|start VSS NND400
* cell instance $210 r0 *1 903,784.7
X$210 \$I2758 clk|done|rst_n|sdi|sdo|sh_en|start
+ clk|done|rst_n|sdi|sdo|sh_en|start clk|done|rst_n|sdi|sdo|sh_en|start
+ clk|done|rst_n|sdi|sdo|sh_en|start clk|done|rst_n|sdi|sdo|sh_en|start VSS
+ NND400
* cell instance $211 r0 *1 926.4,1595.9
X$211 \$I6827 clk|done|rst_n|sdi|sdo|sh_en|start
+ clk|done|rst_n|sdi|sdo|sh_en|start clk|done|rst_n|sdi|sdo|sh_en|start
+ clk|done|rst_n|sdi|sdo|sh_en|start clk|done|rst_n|sdi|sdo|sh_en|start VSS
+ NND400
* cell instance $212 r0 *1 1137,835.4
X$212 \$I6760 clk|done|rst_n|sdi|sdo|sh_en|start
+ clk|done|rst_n|sdi|sdo|sh_en|start \$1075 clk|done|rst_n|sdi|sdo|sh_en|start
+ clk|done|rst_n|sdi|sdo|sh_en|start VSS NND400
* cell instance $213 r0 *1 922.5,1291.7
X$213 \$I6812 clk|done|rst_n|sdi|sdo|sh_en|start
+ clk|done|rst_n|sdi|sdo|sh_en|start clk|done|rst_n|sdi|sdo|sh_en|start
+ clk|done|rst_n|sdi|sdo|sh_en|start clk|done|rst_n|sdi|sdo|sh_en|start VSS
+ NND400
* cell instance $214 r0 *1 988.8,1494.5
X$214 \$I6833 clk|done|rst_n|sdi|sdo|sh_en|start \$2511
+ clk|done|rst_n|sdi|sdo|sh_en|start clk|done|rst_n|sdi|sdo|sh_en|start
+ clk|done|rst_n|sdi|sdo|sh_en|start VSS NND400
* cell instance $215 r0 *1 1449,1342.4
X$215 \$I6823 clk|done|rst_n|sdi|sdo|sh_en|start
+ clk|done|rst_n|sdi|sdo|sh_en|start clk|done|rst_n|sdi|sdo|sh_en|start
+ clk|done|rst_n|sdi|sdo|sh_en|start \$2174 VSS NND400
* cell instance $216 r0 *1 1098,1545.2
X$216 \$I6832 clk|done|rst_n|sdi|sdo|sh_en|start
+ clk|done|rst_n|sdi|sdo|sh_en|start clk|done|rst_n|sdi|sdo|sh_en|start
+ clk|done|rst_n|sdi|sdo|sh_en|start clk|done|rst_n|sdi|sdo|sh_en|start VSS
+ NND400
* cell instance $217 r0 *1 747,1595.9
X$217 \$I6827 clk|done|rst_n|sdi|sdo|sh_en|start
+ clk|done|rst_n|sdi|sdo|sh_en|start clk|done|rst_n|sdi|sdo|sh_en|start
+ clk|done|rst_n|sdi|sdo|sh_en|start clk|done|rst_n|sdi|sdo|sh_en|start VSS
+ NND400
* cell instance $218 r0 *1 1027.8,1545.2
X$218 \$I6832 clk|done|rst_n|sdi|sdo|sh_en|start
+ clk|done|rst_n|sdi|sdo|sh_en|start clk|done|rst_n|sdi|sdo|sh_en|start
+ clk|done|rst_n|sdi|sdo|sh_en|start clk|done|rst_n|sdi|sdo|sh_en|start VSS
+ NND400
* cell instance $219 r0 *1 895.2,1038.2
X$219 \$I6775 \$1505 clk|done|rst_n|sdi|sdo|sh_en|start
+ clk|done|rst_n|sdi|sdo|sh_en|start clk|done|rst_n|sdi|sdo|sh_en|start
+ clk|done|rst_n|sdi|sdo|sh_en|start VSS NND400
* cell instance $220 r0 *1 786,1494.5
X$220 \$I6833 clk|done|rst_n|sdi|sdo|sh_en|start
+ clk|done|rst_n|sdi|sdo|sh_en|start clk|done|rst_n|sdi|sdo|sh_en|start
+ clk|done|rst_n|sdi|sdo|sh_en|start clk|done|rst_n|sdi|sdo|sh_en|start VSS
+ NND400
* cell instance $221 r0 *1 1374.9,480.5
X$221 \$I2747 clk|done|rst_n|sdi|sdo|sh_en|start
+ clk|done|rst_n|sdi|sdo|sh_en|start clk|done|rst_n|sdi|sdo|sh_en|start
+ clk|done|rst_n|sdi|sdo|sh_en|start clk|done|rst_n|sdi|sdo|sh_en|start VSS
+ NND400
* cell instance $222 r0 *1 899.1,1088.9
X$222 \$I6789 clk|done|rst_n|sdi|sdo|sh_en|start
+ clk|done|rst_n|sdi|sdo|sh_en|start clk|done|rst_n|sdi|sdo|sh_en|start
+ clk|done|rst_n|sdi|sdo|sh_en|start clk|done|rst_n|sdi|sdo|sh_en|start VSS
+ NND400
* cell instance $223 r0 *1 1113.6,531.2
X$223 \$I2745 clk|done|rst_n|sdi|sdo|sh_en|start
+ clk|done|rst_n|sdi|sdo|sh_en|start \$356 clk|done|rst_n|sdi|sdo|sh_en|start
+ \$393 VSS NND400
* cell instance $224 r0 *1 1246.2,784.7
X$224 \$I2758 clk|done|rst_n|sdi|sdo|sh_en|start
+ clk|done|rst_n|sdi|sdo|sh_en|start \$986 clk|done|rst_n|sdi|sdo|sh_en|start
+ clk|done|rst_n|sdi|sdo|sh_en|start VSS NND400
* cell instance $225 r0 *1 918.6,886.1
X$225 \$I6796 clk|done|rst_n|sdi|sdo|sh_en|start
+ clk|done|rst_n|sdi|sdo|sh_en|start clk|done|rst_n|sdi|sdo|sh_en|start \$1217
+ \$1162 VSS NND400
* cell instance $226 r0 *1 1156.5,429.8
X$226 \$I2762 clk|done|rst_n|sdi|sdo|sh_en|start
+ clk|done|rst_n|sdi|sdo|sh_en|start clk|done|rst_n|sdi|sdo|sh_en|start
+ clk|done|rst_n|sdi|sdo|sh_en|start clk|done|rst_n|sdi|sdo|sh_en|start VSS
+ AOI400
* cell instance $227 r0 *1 672.9,1139.6
X$227 \$I6814 clk|done|rst_n|sdi|sdo|sh_en|start
+ clk|done|rst_n|sdi|sdo|sh_en|start clk|done|rst_n|sdi|sdo|sh_en|start
+ clk|done|rst_n|sdi|sdo|sh_en|start clk|done|rst_n|sdi|sdo|sh_en|start VSS
+ AOI400
* cell instance $228 r0 *1 1402.2,683.3
X$228 \$I6788 \$795 \$794 clk|done|rst_n|sdi|sdo|sh_en|start
+ clk|done|rst_n|sdi|sdo|sh_en|start clk|done|rst_n|sdi|sdo|sh_en|start VSS
+ AOI400
* cell instance $229 r0 *1 1027.8,1088.9
X$229 \$I6789 clk|done|rst_n|sdi|sdo|sh_en|start
+ clk|done|rst_n|sdi|sdo|sh_en|start clk|done|rst_n|sdi|sdo|sh_en|start
+ clk|done|rst_n|sdi|sdo|sh_en|start clk|done|rst_n|sdi|sdo|sh_en|start VSS
+ AOI400
* cell instance $230 r0 *1 633.9,1443.8
X$230 \$I6819 clk|done|rst_n|sdi|sdo|sh_en|start
+ clk|done|rst_n|sdi|sdo|sh_en|start clk|done|rst_n|sdi|sdo|sh_en|start
+ clk|done|rst_n|sdi|sdo|sh_en|start clk|done|rst_n|sdi|sdo|sh_en|start VSS
+ AOI400
* cell instance $231 r0 *1 1527,784.7
X$231 \$I2758 clk|done|rst_n|sdi|sdo|sh_en|start
+ clk|done|rst_n|sdi|sdo|sh_en|start clk|done|rst_n|sdi|sdo|sh_en|start
+ clk|done|rst_n|sdi|sdo|sh_en|start clk|done|rst_n|sdi|sdo|sh_en|start VSS
+ AOI400
* cell instance $232 r0 *1 1503.6,835.4
X$232 \$I6760 \$1087 \$1032 clk|done|rst_n|sdi|sdo|sh_en|start
+ clk|done|rst_n|sdi|sdo|sh_en|start clk|done|rst_n|sdi|sdo|sh_en|start VSS
+ AOI400
* cell instance $233 r0 *1 1355.4,784.7
X$233 \$I2758 clk|done|rst_n|sdi|sdo|sh_en|start
+ clk|done|rst_n|sdi|sdo|sh_en|start clk|done|rst_n|sdi|sdo|sh_en|start
+ clk|done|rst_n|sdi|sdo|sh_en|start clk|done|rst_n|sdi|sdo|sh_en|start VSS
+ AOI400
* cell instance $234 r0 *1 903,1545.2
X$234 \$I6832 clk|done|rst_n|sdi|sdo|sh_en|start
+ clk|done|rst_n|sdi|sdo|sh_en|start clk|done|rst_n|sdi|sdo|sh_en|start
+ clk|done|rst_n|sdi|sdo|sh_en|start clk|done|rst_n|sdi|sdo|sh_en|start VSS
+ AOI400
* cell instance $235 r0 *1 778.2,1291.7
X$235 \$I6812 \$2061 clk|done|rst_n|sdi|sdo|sh_en|start
+ clk|done|rst_n|sdi|sdo|sh_en|start clk|done|rst_n|sdi|sdo|sh_en|start
+ clk|done|rst_n|sdi|sdo|sh_en|start VSS AOI400
* cell instance $236 r0 *1 1164.3,1088.9
X$236 \$I6789 clk|done|rst_n|sdi|sdo|sh_en|start
+ clk|done|rst_n|sdi|sdo|sh_en|start clk|done|rst_n|sdi|sdo|sh_en|start
+ clk|done|rst_n|sdi|sdo|sh_en|start clk|done|rst_n|sdi|sdo|sh_en|start VSS
+ AOI400
* cell instance $237 r0 *1 1355.4,734
X$237 \$I2783 \$900 clk|done|rst_n|sdi|sdo|sh_en|start
+ clk|done|rst_n|sdi|sdo|sh_en|start clk|done|rst_n|sdi|sdo|sh_en|start
+ clk|done|rst_n|sdi|sdo|sh_en|start VSS AOI400
* cell instance $238 r0 *1 1059,1088.9
X$238 \$I6789 clk|done|rst_n|sdi|sdo|sh_en|start \$1511
+ clk|done|rst_n|sdi|sdo|sh_en|start clk|done|rst_n|sdi|sdo|sh_en|start
+ clk|done|rst_n|sdi|sdo|sh_en|start VSS AOI400
* cell instance $239 r0 *1 883.5,936.8
X$239 \$I6730 clk|done|rst_n|sdi|sdo|sh_en|start
+ clk|done|rst_n|sdi|sdo|sh_en|start clk|done|rst_n|sdi|sdo|sh_en|start
+ clk|done|rst_n|sdi|sdo|sh_en|start clk|done|rst_n|sdi|sdo|sh_en|start VSS
+ AOI400
* cell instance $240 r0 *1 1062.9,581.9
X$240 \$I2828 clk|done|rst_n|sdi|sdo|sh_en|start
+ clk|done|rst_n|sdi|sdo|sh_en|start clk|done|rst_n|sdi|sdo|sh_en|start
+ clk|done|rst_n|sdi|sdo|sh_en|start clk|done|rst_n|sdi|sdo|sh_en|start VSS
+ AOI400
* cell instance $241 r0 *1 1491.9,531.2
X$241 \$I2745 \$475 clk|done|rst_n|sdi|sdo|sh_en|start
+ clk|done|rst_n|sdi|sdo|sh_en|start clk|done|rst_n|sdi|sdo|sh_en|start
+ clk|done|rst_n|sdi|sdo|sh_en|start VSS AOI400
* cell instance $242 r0 *1 1382.7,429.8
X$242 \$I2762 clk|done|rst_n|sdi|sdo|sh_en|start
+ clk|done|rst_n|sdi|sdo|sh_en|start clk|done|rst_n|sdi|sdo|sh_en|start
+ clk|done|rst_n|sdi|sdo|sh_en|start clk|done|rst_n|sdi|sdo|sh_en|start VSS
+ AOI400
* cell instance $243 r0 *1 1039.5,1393.1
X$243 \$I6830 clk|done|rst_n|sdi|sdo|sh_en|start
+ clk|done|rst_n|sdi|sdo|sh_en|start clk|done|rst_n|sdi|sdo|sh_en|start
+ clk|done|rst_n|sdi|sdo|sh_en|start clk|done|rst_n|sdi|sdo|sh_en|start VSS
+ AOI400
* cell instance $244 r0 *1 1413.9,987.5
X$244 \$I6725 clk|done|rst_n|sdi|sdo|sh_en|start
+ clk|done|rst_n|sdi|sdo|sh_en|start clk|done|rst_n|sdi|sdo|sh_en|start
+ clk|done|rst_n|sdi|sdo|sh_en|start clk|done|rst_n|sdi|sdo|sh_en|start VSS
+ AOI400
* cell instance $245 r0 *1 591,1190.3
X$245 \$I6808 clk|done|rst_n|sdi|sdo|sh_en|start
+ clk|done|rst_n|sdi|sdo|sh_en|start clk|done|rst_n|sdi|sdo|sh_en|start
+ clk|done|rst_n|sdi|sdo|sh_en|start clk|done|rst_n|sdi|sdo|sh_en|start VSS
+ AOI400
* cell instance $246 r0 *1 1273.5,1088.9
X$246 \$I6789 clk|done|rst_n|sdi|sdo|sh_en|start
+ clk|done|rst_n|sdi|sdo|sh_en|start clk|done|rst_n|sdi|sdo|sh_en|start
+ clk|done|rst_n|sdi|sdo|sh_en|start clk|done|rst_n|sdi|sdo|sh_en|start VSS
+ AOI400
* cell instance $247 r0 *1 786,1088.9
X$247 \$I6789 clk|done|rst_n|sdi|sdo|sh_en|start
+ clk|done|rst_n|sdi|sdo|sh_en|start clk|done|rst_n|sdi|sdo|sh_en|start
+ clk|done|rst_n|sdi|sdo|sh_en|start clk|done|rst_n|sdi|sdo|sh_en|start VSS
+ AOI400
* cell instance $248 r0 *1 1343.7,531.2
X$248 \$I2745 clk|done|rst_n|sdi|sdo|sh_en|start
+ clk|done|rst_n|sdi|sdo|sh_en|start clk|done|rst_n|sdi|sdo|sh_en|start
+ clk|done|rst_n|sdi|sdo|sh_en|start clk|done|rst_n|sdi|sdo|sh_en|start VSS
+ AOI400
* cell instance $249 r0 *1 583.2,1342.4
X$249 \$I6823 clk|done|rst_n|sdi|sdo|sh_en|start
+ clk|done|rst_n|sdi|sdo|sh_en|start clk|done|rst_n|sdi|sdo|sh_en|start
+ clk|done|rst_n|sdi|sdo|sh_en|start clk|done|rst_n|sdi|sdo|sh_en|start VSS
+ AOI400
* cell instance $250 r0 *1 1390.5,784.7
X$250 \$I2758 clk|done|rst_n|sdi|sdo|sh_en|start \$936
+ clk|done|rst_n|sdi|sdo|sh_en|start clk|done|rst_n|sdi|sdo|sh_en|start
+ clk|done|rst_n|sdi|sdo|sh_en|start VSS AOI400
* cell instance $251 r0 *1 1289.1,683.3
X$251 \$I6788 clk|done|rst_n|sdi|sdo|sh_en|start \$783
+ clk|done|rst_n|sdi|sdo|sh_en|start clk|done|rst_n|sdi|sdo|sh_en|start
+ clk|done|rst_n|sdi|sdo|sh_en|start VSS AOI400
* cell instance $252 r0 *1 1250.1,683.3
X$252 \$I6788 clk|done|rst_n|sdi|sdo|sh_en|start
+ clk|done|rst_n|sdi|sdo|sh_en|start clk|done|rst_n|sdi|sdo|sh_en|start
+ clk|done|rst_n|sdi|sdo|sh_en|start clk|done|rst_n|sdi|sdo|sh_en|start VSS
+ AOI400
* cell instance $253 r0 *1 875.7,886.1
X$253 \$I6796 clk|done|rst_n|sdi|sdo|sh_en|start
+ clk|done|rst_n|sdi|sdo|sh_en|start clk|done|rst_n|sdi|sdo|sh_en|start
+ clk|done|rst_n|sdi|sdo|sh_en|start clk|done|rst_n|sdi|sdo|sh_en|start VSS
+ AOI400
* cell instance $254 r0 *1 1382.7,987.5
X$254 \$I6725 \$1371 clk|done|rst_n|sdi|sdo|sh_en|start
+ clk|done|rst_n|sdi|sdo|sh_en|start clk|done|rst_n|sdi|sdo|sh_en|start
+ clk|done|rst_n|sdi|sdo|sh_en|start VSS AOI400
* cell instance $255 r0 *1 1187.7,683.3
X$255 \$I6788 clk|done|rst_n|sdi|sdo|sh_en|start
+ clk|done|rst_n|sdi|sdo|sh_en|start clk|done|rst_n|sdi|sdo|sh_en|start
+ clk|done|rst_n|sdi|sdo|sh_en|start clk|done|rst_n|sdi|sdo|sh_en|start VSS
+ AOI400
* cell instance $256 r0 *1 1527,886.1
X$256 \$I6796 clk|done|rst_n|sdi|sdo|sh_en|start
+ clk|done|rst_n|sdi|sdo|sh_en|start clk|done|rst_n|sdi|sdo|sh_en|start
+ clk|done|rst_n|sdi|sdo|sh_en|start clk|done|rst_n|sdi|sdo|sh_en|start VSS
+ AOI400
* cell instance $257 r0 *1 774.3,1595.9
X$257 \$I6827 \$2646 clk|done|rst_n|sdi|sdo|sh_en|start
+ clk|done|rst_n|sdi|sdo|sh_en|start clk|done|rst_n|sdi|sdo|sh_en|start
+ clk|done|rst_n|sdi|sdo|sh_en|start VSS AOI400
* cell instance $258 r0 *1 895.2,683.3
X$258 \$I6788 clk|done|rst_n|sdi|sdo|sh_en|start
+ clk|done|rst_n|sdi|sdo|sh_en|start clk|done|rst_n|sdi|sdo|sh_en|start
+ clk|done|rst_n|sdi|sdo|sh_en|start clk|done|rst_n|sdi|sdo|sh_en|start VSS
+ AOI400
* cell instance $259 r0 *1 1066.8,1545.2
X$259 \$I6832 clk|done|rst_n|sdi|sdo|sh_en|start
+ clk|done|rst_n|sdi|sdo|sh_en|start clk|done|rst_n|sdi|sdo|sh_en|start
+ clk|done|rst_n|sdi|sdo|sh_en|start clk|done|rst_n|sdi|sdo|sh_en|start VSS
+ AOI400
* cell instance $260 r0 *1 1355.4,683.3
X$260 \$I6788 clk|done|rst_n|sdi|sdo|sh_en|start
+ clk|done|rst_n|sdi|sdo|sh_en|start clk|done|rst_n|sdi|sdo|sh_en|start
+ clk|done|rst_n|sdi|sdo|sh_en|start clk|done|rst_n|sdi|sdo|sh_en|start VSS
+ AOI400
* cell instance $261 r0 *1 1133.1,734
X$261 \$I2783 clk|done|rst_n|sdi|sdo|sh_en|start
+ clk|done|rst_n|sdi|sdo|sh_en|start clk|done|rst_n|sdi|sdo|sh_en|start
+ clk|done|rst_n|sdi|sdo|sh_en|start clk|done|rst_n|sdi|sdo|sh_en|start VSS
+ AOI400
* cell instance $262 r0 *1 1082.4,936.8
X$262 \$I6730 clk|done|rst_n|sdi|sdo|sh_en|start
+ clk|done|rst_n|sdi|sdo|sh_en|start clk|done|rst_n|sdi|sdo|sh_en|start
+ clk|done|rst_n|sdi|sdo|sh_en|start clk|done|rst_n|sdi|sdo|sh_en|start VSS
+ AOI400
* cell instance $263 r0 *1 969.3,734
X$263 \$I2783 clk|done|rst_n|sdi|sdo|sh_en|start
+ clk|done|rst_n|sdi|sdo|sh_en|start clk|done|rst_n|sdi|sdo|sh_en|start
+ clk|done|rst_n|sdi|sdo|sh_en|start clk|done|rst_n|sdi|sdo|sh_en|start VSS
+ AOI400
* cell instance $264 r0 *1 1293,1393.1
X$264 \$I6830 clk|done|rst_n|sdi|sdo|sh_en|start
+ clk|done|rst_n|sdi|sdo|sh_en|start clk|done|rst_n|sdi|sdo|sh_en|start
+ clk|done|rst_n|sdi|sdo|sh_en|start clk|done|rst_n|sdi|sdo|sh_en|start VSS
+ AOI400
* cell instance $265 r0 *1 1503.6,632.6
X$265 \$I6781 \$702 clk|done|rst_n|sdi|sdo|sh_en|start
+ clk|done|rst_n|sdi|sdo|sh_en|start clk|done|rst_n|sdi|sdo|sh_en|start
+ clk|done|rst_n|sdi|sdo|sh_en|start VSS AOI400
* cell instance $266 r0 *1 540.3,1291.7
X$266 \$I6812 clk|done|rst_n|sdi|sdo|sh_en|start
+ clk|done|rst_n|sdi|sdo|sh_en|start clk|done|rst_n|sdi|sdo|sh_en|start
+ clk|done|rst_n|sdi|sdo|sh_en|start clk|done|rst_n|sdi|sdo|sh_en|start VSS
+ AOI400
* cell instance $267 r0 *1 875.7,734
X$267 \$I2783 clk|done|rst_n|sdi|sdo|sh_en|start
+ clk|done|rst_n|sdi|sdo|sh_en|start clk|done|rst_n|sdi|sdo|sh_en|start
+ clk|done|rst_n|sdi|sdo|sh_en|start clk|done|rst_n|sdi|sdo|sh_en|start VSS
+ AOI400
* cell instance $268 r0 *1 392.1,784.7
X$268 clk|done|rst_n|sdi|sdo|sh_en|start clk|done|rst_n|sdi|sdo|sh_en|start
+ clk|done|rst_n|sdi|sdo|sh_en|start clk|done|rst_n|sdi|sdo|sh_en|start
+ clk|done|rst_n|sdi|sdo|sh_en|start clk|done|rst_n|sdi|sdo|sh_en|start
+ clk|done|rst_n|sdi|sdo|sh_en|start \$I2758 VSS MX4100
* cell instance $269 r0 *1 384.3,1342.4
X$269 clk|done|rst_n|sdi|sdo|sh_en|start clk|done|rst_n|sdi|sdo|sh_en|start
+ clk|done|rst_n|sdi|sdo|sh_en|start clk|done|rst_n|sdi|sdo|sh_en|start
+ clk|done|rst_n|sdi|sdo|sh_en|start clk|done|rst_n|sdi|sdo|sh_en|start
+ clk|done|rst_n|sdi|sdo|sh_en|start \$I6823 VSS MX4100
* cell instance $270 r0 *1 883.5,379.1
X$270 clk|done|rst_n|sdi|sdo|sh_en|start clk|done|rst_n|sdi|sdo|sh_en|start
+ clk|done|rst_n|sdi|sdo|sh_en|start clk|done|rst_n|sdi|sdo|sh_en|start
+ clk|done|rst_n|sdi|sdo|sh_en|start clk|done|rst_n|sdi|sdo|sh_en|start
+ clk|done|rst_n|sdi|sdo|sh_en|start \$I2572 VSS MX4100
* cell instance $271 r0 *1 754.8,936.8
X$271 clk|done|rst_n|sdi|sdo|sh_en|start clk|done|rst_n|sdi|sdo|sh_en|start
+ clk|done|rst_n|sdi|sdo|sh_en|start clk|done|rst_n|sdi|sdo|sh_en|start
+ clk|done|rst_n|sdi|sdo|sh_en|start clk|done|rst_n|sdi|sdo|sh_en|start
+ clk|done|rst_n|sdi|sdo|sh_en|start \$I6730 VSS MX4100
* cell instance $272 r0 *1 415.5,1494.5
X$272 \$2343 clk|done|rst_n|sdi|sdo|sh_en|start
+ clk|done|rst_n|sdi|sdo|sh_en|start clk|done|rst_n|sdi|sdo|sh_en|start
+ clk|done|rst_n|sdi|sdo|sh_en|start clk|done|rst_n|sdi|sdo|sh_en|start
+ clk|done|rst_n|sdi|sdo|sh_en|start \$I6833 VSS MX4100
* cell instance $273 r0 *1 774.3,683.3
X$273 clk|done|rst_n|sdi|sdo|sh_en|start clk|done|rst_n|sdi|sdo|sh_en|start
+ clk|done|rst_n|sdi|sdo|sh_en|start clk|done|rst_n|sdi|sdo|sh_en|start
+ clk|done|rst_n|sdi|sdo|sh_en|start clk|done|rst_n|sdi|sdo|sh_en|start
+ clk|done|rst_n|sdi|sdo|sh_en|start \$I6788 VSS MX4100
* cell instance $274 r0 *1 384.3,1139.6
X$274 \$1623 clk|done|rst_n|sdi|sdo|sh_en|start
+ clk|done|rst_n|sdi|sdo|sh_en|start \$1745 clk|done|rst_n|sdi|sdo|sh_en|start
+ clk|done|rst_n|sdi|sdo|sh_en|start clk|done|rst_n|sdi|sdo|sh_en|start \$I6814
+ VSS MX4100
* cell instance $275 r0 *1 949.8,1291.7
X$275 clk|done|rst_n|sdi|sdo|sh_en|start clk|done|rst_n|sdi|sdo|sh_en|start
+ clk|done|rst_n|sdi|sdo|sh_en|start clk|done|rst_n|sdi|sdo|sh_en|start
+ clk|done|rst_n|sdi|sdo|sh_en|start clk|done|rst_n|sdi|sdo|sh_en|start
+ clk|done|rst_n|sdi|sdo|sh_en|start \$I6812 VSS MX4100
* cell instance $276 r0 *1 860.1,531.2
X$276 clk|done|rst_n|sdi|sdo|sh_en|start clk|done|rst_n|sdi|sdo|sh_en|start
+ clk|done|rst_n|sdi|sdo|sh_en|start \$555 clk|done|rst_n|sdi|sdo|sh_en|start
+ clk|done|rst_n|sdi|sdo|sh_en|start clk|done|rst_n|sdi|sdo|sh_en|start \$I2745
+ VSS MX4100
* cell instance $277 r0 *1 384.3,936.8
X$277 clk|done|rst_n|sdi|sdo|sh_en|start clk|done|rst_n|sdi|sdo|sh_en|start
+ \$1259 \$1144 clk|done|rst_n|sdi|sdo|sh_en|start
+ clk|done|rst_n|sdi|sdo|sh_en|start clk|done|rst_n|sdi|sdo|sh_en|start \$I6730
+ VSS MX4100
* cell instance $278 r0 *1 563.7,835.4
X$278 \$1061 clk|done|rst_n|sdi|sdo|sh_en|start
+ clk|done|rst_n|sdi|sdo|sh_en|start clk|done|rst_n|sdi|sdo|sh_en|start
+ clk|done|rst_n|sdi|sdo|sh_en|start clk|done|rst_n|sdi|sdo|sh_en|start
+ clk|done|rst_n|sdi|sdo|sh_en|start \$I6760 VSS MX4100
* cell instance $279 r0 *1 587.1,581.9
X$279 clk|done|rst_n|sdi|sdo|sh_en|start clk|done|rst_n|sdi|sdo|sh_en|start
+ clk|done|rst_n|sdi|sdo|sh_en|start clk|done|rst_n|sdi|sdo|sh_en|start
+ clk|done|rst_n|sdi|sdo|sh_en|start clk|done|rst_n|sdi|sdo|sh_en|start
+ clk|done|rst_n|sdi|sdo|sh_en|start \$I2828 VSS MX4100
* cell instance $280 r0 *1 415.5,632.6
X$280 clk|done|rst_n|sdi|sdo|sh_en|start clk|done|rst_n|sdi|sdo|sh_en|start
+ clk|done|rst_n|sdi|sdo|sh_en|start clk|done|rst_n|sdi|sdo|sh_en|start
+ clk|done|rst_n|sdi|sdo|sh_en|start clk|done|rst_n|sdi|sdo|sh_en|start
+ clk|done|rst_n|sdi|sdo|sh_en|start \$I6781 VSS MX4100
* cell instance $281 r0 *1 1519.2,1494.5
X$281 \$I6833 clk|done|rst_n|sdi|sdo|sh_en|start
+ clk|done|rst_n|sdi|sdo|sh_en|start clk|done|rst_n|sdi|sdo|sh_en|start VSS
+ NND200
* cell instance $282 r0 *1 1468.5,1494.5
X$282 \$I6833 clk|done|rst_n|sdi|sdo|sh_en|start
+ clk|done|rst_n|sdi|sdo|sh_en|start clk|done|rst_n|sdi|sdo|sh_en|start VSS
+ NND200
* cell instance $283 r0 *1 1199.4,429.8
X$283 \$I2762 clk|done|rst_n|sdi|sdo|sh_en|start
+ clk|done|rst_n|sdi|sdo|sh_en|start clk|done|rst_n|sdi|sdo|sh_en|start VSS
+ NND200
* cell instance $284 r0 *1 1055.1,1494.5
X$284 \$I6833 \$2516 clk|done|rst_n|sdi|sdo|sh_en|start
+ clk|done|rst_n|sdi|sdo|sh_en|start VSS NND200
* cell instance $285 r0 *1 1191.6,835.4
X$285 \$I6760 clk|done|rst_n|sdi|sdo|sh_en|start
+ clk|done|rst_n|sdi|sdo|sh_en|start clk|done|rst_n|sdi|sdo|sh_en|start VSS
+ NND200
* cell instance $286 r0 *1 1172.1,1342.4
X$286 \$I6823 clk|done|rst_n|sdi|sdo|sh_en|start
+ clk|done|rst_n|sdi|sdo|sh_en|start clk|done|rst_n|sdi|sdo|sh_en|start VSS
+ NND200
* cell instance $287 r0 *1 887.4,784.7
X$287 \$I2758 clk|done|rst_n|sdi|sdo|sh_en|start
+ clk|done|rst_n|sdi|sdo|sh_en|start clk|done|rst_n|sdi|sdo|sh_en|start VSS
+ NND200
* cell instance $288 r0 *1 1320.3,1038.2
X$288 \$I6775 \$1433 clk|done|rst_n|sdi|sdo|sh_en|start
+ clk|done|rst_n|sdi|sdo|sh_en|start VSS NND200
* cell instance $289 r0 *1 1558.2,1393.1
X$289 \$I6830 clk|done|rst_n|sdi|sdo|sh_en|start
+ clk|done|rst_n|sdi|sdo|sh_en|start clk|done|rst_n|sdi|sdo|sh_en|start VSS
+ NND200
* cell instance $290 r0 *1 1441.2,632.6
X$290 \$I6781 \$698 clk|done|rst_n|sdi|sdo|sh_en|start
+ clk|done|rst_n|sdi|sdo|sh_en|start VSS NND200
* cell instance $291 r0 *1 1059,1342.4
X$291 \$I6823 clk|done|rst_n|sdi|sdo|sh_en|start
+ clk|done|rst_n|sdi|sdo|sh_en|start clk|done|rst_n|sdi|sdo|sh_en|start VSS
+ NND200
* cell instance $292 r0 *1 860.1,1595.9
X$292 \$I6827 \$2647 clk|done|rst_n|sdi|sdo|sh_en|start
+ clk|done|rst_n|sdi|sdo|sh_en|start VSS NND200
* cell instance $293 r0 *1 1152.6,1443.8
X$293 \$I6819 clk|done|rst_n|sdi|sdo|sh_en|start
+ clk|done|rst_n|sdi|sdo|sh_en|start clk|done|rst_n|sdi|sdo|sh_en|start VSS
+ NND200
* cell instance $294 r0 *1 875.7,1443.8
X$294 \$I6819 clk|done|rst_n|sdi|sdo|sh_en|start
+ clk|done|rst_n|sdi|sdo|sh_en|start clk|done|rst_n|sdi|sdo|sh_en|start VSS
+ NND200
* cell instance $295 r0 *1 1534.8,632.6
X$295 \$I6781 clk|done|rst_n|sdi|sdo|sh_en|start \$702
+ clk|done|rst_n|sdi|sdo|sh_en|start VSS NND200
* cell instance $296 r0 *1 1168.2,1494.5
X$296 \$I6833 \$2415 clk|done|rst_n|sdi|sdo|sh_en|start
+ clk|done|rst_n|sdi|sdo|sh_en|start VSS NND200
* cell instance $297 r0 *1 996.6,1595.9
X$297 \$I6827 clk|done|rst_n|sdi|sdo|sh_en|start
+ clk|done|rst_n|sdi|sdo|sh_en|start clk|done|rst_n|sdi|sdo|sh_en|start VSS
+ NND200
* cell instance $298 r0 *1 957.6,1241
X$298 \$I6818 clk|done|rst_n|sdi|sdo|sh_en|start
+ clk|done|rst_n|sdi|sdo|sh_en|start clk|done|rst_n|sdi|sdo|sh_en|start VSS
+ NND200
* cell instance $299 r0 *1 1460.7,1393.1
X$299 \$I6830 \$2220 clk|done|rst_n|sdi|sdo|sh_en|start
+ clk|done|rst_n|sdi|sdo|sh_en|start VSS NND200
* cell instance $300 r0 *1 1339.8,683.3
X$300 \$I6788 clk|done|rst_n|sdi|sdo|sh_en|start
+ clk|done|rst_n|sdi|sdo|sh_en|start clk|done|rst_n|sdi|sdo|sh_en|start VSS
+ NND200
* cell instance $301 r0 *1 930.3,1088.9
X$301 \$I6789 clk|done|rst_n|sdi|sdo|sh_en|start \$1639
+ clk|done|rst_n|sdi|sdo|sh_en|start VSS NND200
* cell instance $302 r0 *1 1339.8,429.8
X$302 \$I2762 \$195 clk|done|rst_n|sdi|sdo|sh_en|start
+ clk|done|rst_n|sdi|sdo|sh_en|start VSS NND200
* cell instance $303 r0 *1 1039.5,1494.5
X$303 \$I6833 clk|done|rst_n|sdi|sdo|sh_en|start
+ clk|done|rst_n|sdi|sdo|sh_en|start clk|done|rst_n|sdi|sdo|sh_en|start VSS
+ NND200
* cell instance $304 r0 *1 1230.6,886.1
X$304 \$I6796 clk|done|rst_n|sdi|sdo|sh_en|start
+ clk|done|rst_n|sdi|sdo|sh_en|start clk|done|rst_n|sdi|sdo|sh_en|start VSS
+ NND200
* cell instance $305 r0 *1 1215,886.1
X$305 \$I6796 clk|done|rst_n|sdi|sdo|sh_en|start
+ clk|done|rst_n|sdi|sdo|sh_en|start clk|done|rst_n|sdi|sdo|sh_en|start VSS
+ NND200
* cell instance $306 r0 *1 805.5,1443.8
X$306 \$I6819 clk|done|rst_n|sdi|sdo|sh_en|start
+ clk|done|rst_n|sdi|sdo|sh_en|start clk|done|rst_n|sdi|sdo|sh_en|start VSS
+ NND200
* cell instance $307 r0 *1 1062.9,1443.8
X$307 \$I6819 clk|done|rst_n|sdi|sdo|sh_en|start \$2370
+ clk|done|rst_n|sdi|sdo|sh_en|start VSS NND200
* cell instance $308 r0 *1 524.7,1291.7
X$308 \$I6812 clk|done|rst_n|sdi|sdo|sh_en|start
+ clk|done|rst_n|sdi|sdo|sh_en|start clk|done|rst_n|sdi|sdo|sh_en|start VSS
+ NND200
* cell instance $309 r0 *1 1195.5,1494.5
X$309 \$I6833 clk|done|rst_n|sdi|sdo|sh_en|start
+ clk|done|rst_n|sdi|sdo|sh_en|start clk|done|rst_n|sdi|sdo|sh_en|start VSS
+ NND200
* cell instance $310 r0 *1 938.1,1038.2
X$310 \$I6775 clk|done|rst_n|sdi|sdo|sh_en|start
+ clk|done|rst_n|sdi|sdo|sh_en|start clk|done|rst_n|sdi|sdo|sh_en|start VSS
+ NND200
* cell instance $311 r0 *1 1413.9,429.8
X$311 \$I2762 clk|done|rst_n|sdi|sdo|sh_en|start
+ clk|done|rst_n|sdi|sdo|sh_en|start clk|done|rst_n|sdi|sdo|sh_en|start VSS
+ NND200
* cell instance $312 r0 *1 1402.2,734
X$312 \$I2783 \$794 clk|done|rst_n|sdi|sdo|sh_en|start
+ clk|done|rst_n|sdi|sdo|sh_en|start VSS NND200
* cell instance $313 r0 *1 1546.5,531.2
X$313 \$I2745 clk|done|rst_n|sdi|sdo|sh_en|start
+ clk|done|rst_n|sdi|sdo|sh_en|start clk|done|rst_n|sdi|sdo|sh_en|start VSS
+ NND200
* cell instance $314 r0 *1 567.6,1443.8
X$314 \$I6819 clk|done|rst_n|sdi|sdo|sh_en|start
+ clk|done|rst_n|sdi|sdo|sh_en|start clk|done|rst_n|sdi|sdo|sh_en|start VSS
+ NND200
* cell instance $315 r0 *1 871.8,784.7
X$315 \$I2758 clk|done|rst_n|sdi|sdo|sh_en|start
+ clk|done|rst_n|sdi|sdo|sh_en|start clk|done|rst_n|sdi|sdo|sh_en|start VSS
+ NND200
* cell instance $316 r0 *1 552,1443.8
X$316 \$I6819 clk|done|rst_n|sdi|sdo|sh_en|start
+ clk|done|rst_n|sdi|sdo|sh_en|start clk|done|rst_n|sdi|sdo|sh_en|start VSS
+ NND200
* cell instance $317 r0 *1 575.4,784.7
X$317 \$I2758 clk|done|rst_n|sdi|sdo|sh_en|start
+ clk|done|rst_n|sdi|sdo|sh_en|start clk|done|rst_n|sdi|sdo|sh_en|start VSS
+ NND200
* cell instance $318 r0 *1 614.4,1443.8
X$318 \$I6819 clk|done|rst_n|sdi|sdo|sh_en|start
+ clk|done|rst_n|sdi|sdo|sh_en|start clk|done|rst_n|sdi|sdo|sh_en|start VSS
+ NND200
* cell instance $319 r0 *1 1215,1139.6
X$319 \$I6814 clk|done|rst_n|sdi|sdo|sh_en|start
+ clk|done|rst_n|sdi|sdo|sh_en|start clk|done|rst_n|sdi|sdo|sh_en|start VSS
+ NND200
* cell instance $320 r0 *1 1659.6,886.1
X$320 \$I6796 \$1229 clk|done|rst_n|sdi|sdo|sh_en|start
+ clk|done|rst_n|sdi|sdo|sh_en|start VSS NND200
* cell instance $321 r0 *1 723.6,1190.3
X$321 \$I6808 clk|done|rst_n|sdi|sdo|sh_en|start
+ clk|done|rst_n|sdi|sdo|sh_en|start clk|done|rst_n|sdi|sdo|sh_en|start VSS
+ NND200
* cell instance $322 r0 *1 840.6,1494.5
X$322 \$I6833 clk|done|rst_n|sdi|sdo|sh_en|start
+ clk|done|rst_n|sdi|sdo|sh_en|start clk|done|rst_n|sdi|sdo|sh_en|start VSS
+ NND200
* cell instance $323 r0 *1 770.4,1494.5
X$323 \$I6833 clk|done|rst_n|sdi|sdo|sh_en|start
+ clk|done|rst_n|sdi|sdo|sh_en|start clk|done|rst_n|sdi|sdo|sh_en|start VSS
+ NND200
* cell instance $324 r0 *1 1027.8,1139.6
X$324 \$I6814 clk|done|rst_n|sdi|sdo|sh_en|start
+ clk|done|rst_n|sdi|sdo|sh_en|start clk|done|rst_n|sdi|sdo|sh_en|start VSS
+ NND200
* cell instance $325 r0 *1 1230.6,784.7
X$325 \$I2758 \$986 clk|done|rst_n|sdi|sdo|sh_en|start
+ clk|done|rst_n|sdi|sdo|sh_en|start VSS NND200
* cell instance $326 r0 *1 1495.8,734
X$326 \$I2783 clk|done|rst_n|sdi|sdo|sh_en|start
+ clk|done|rst_n|sdi|sdo|sh_en|start clk|done|rst_n|sdi|sdo|sh_en|start VSS
+ NND200
* cell instance $327 r0 *1 540.3,480.5
X$327 \$I2747 clk|done|rst_n|sdi|sdo|sh_en|start
+ clk|done|rst_n|sdi|sdo|sh_en|start clk|done|rst_n|sdi|sdo|sh_en|start VSS
+ NND200
* cell instance $328 r0 *1 1433.4,379.1
X$328 \$I2572 clk|done|rst_n|sdi|sdo|sh_en|start
+ clk|done|rst_n|sdi|sdo|sh_en|start clk|done|rst_n|sdi|sdo|sh_en|start VSS
+ NND200
* cell instance $329 r0 *1 1304.7,1038.2
X$329 \$I6775 clk|done|rst_n|sdi|sdo|sh_en|start
+ clk|done|rst_n|sdi|sdo|sh_en|start clk|done|rst_n|sdi|sdo|sh_en|start VSS
+ NND200
* cell instance $330 r0 *1 1511.4,886.1
X$330 \$I6796 clk|done|rst_n|sdi|sdo|sh_en|start
+ clk|done|rst_n|sdi|sdo|sh_en|start clk|done|rst_n|sdi|sdo|sh_en|start VSS
+ NND200
* cell instance $331 r0 *1 1324.2,683.3
X$331 \$I6788 clk|done|rst_n|sdi|sdo|sh_en|start
+ clk|done|rst_n|sdi|sdo|sh_en|start clk|done|rst_n|sdi|sdo|sh_en|start VSS
+ NND200
* cell instance $332 r0 *1 1269.6,734
X$332 \$I2783 clk|done|rst_n|sdi|sdo|sh_en|start
+ clk|done|rst_n|sdi|sdo|sh_en|start clk|done|rst_n|sdi|sdo|sh_en|start VSS
+ NND200
* cell instance $333 r0 *1 1168.2,734
X$333 \$I2783 clk|done|rst_n|sdi|sdo|sh_en|start
+ clk|done|rst_n|sdi|sdo|sh_en|start clk|done|rst_n|sdi|sdo|sh_en|start VSS
+ NND200
* cell instance $334 r0 *1 762.6,1291.7
X$334 \$I6812 clk|done|rst_n|sdi|sdo|sh_en|start
+ clk|done|rst_n|sdi|sdo|sh_en|start clk|done|rst_n|sdi|sdo|sh_en|start VSS
+ NND200
* cell instance $335 r0 *1 1503.6,581.9
X$335 \$I2828 clk|done|rst_n|sdi|sdo|sh_en|start
+ clk|done|rst_n|sdi|sdo|sh_en|start clk|done|rst_n|sdi|sdo|sh_en|start VSS
+ NND200
* cell instance $336 r0 *1 1488,835.4
X$336 \$I6760 clk|done|rst_n|sdi|sdo|sh_en|start
+ clk|done|rst_n|sdi|sdo|sh_en|start clk|done|rst_n|sdi|sdo|sh_en|start VSS
+ NND200
* cell instance $337 r0 *1 692.4,1241
X$337 \$I6818 clk|done|rst_n|sdi|sdo|sh_en|start
+ clk|done|rst_n|sdi|sdo|sh_en|start clk|done|rst_n|sdi|sdo|sh_en|start VSS
+ NND200
* cell instance $338 r0 *1 1234.5,683.3
X$338 \$I6788 \$783 clk|done|rst_n|sdi|sdo|sh_en|start
+ clk|done|rst_n|sdi|sdo|sh_en|start VSS NND200
* cell instance $339 r0 *1 571.5,1291.7
X$339 \$I6812 clk|done|rst_n|sdi|sdo|sh_en|start
+ clk|done|rst_n|sdi|sdo|sh_en|start clk|done|rst_n|sdi|sdo|sh_en|start VSS
+ NND200
* cell instance $340 r0 *1 1398.3,1443.8
X$340 \$I6819 clk|done|rst_n|sdi|sdo|sh_en|start
+ clk|done|rst_n|sdi|sdo|sh_en|start clk|done|rst_n|sdi|sdo|sh_en|start VSS
+ NND200
* cell instance $341 r0 *1 747,1291.7
X$341 \$I6812 clk|done|rst_n|sdi|sdo|sh_en|start
+ clk|done|rst_n|sdi|sdo|sh_en|start clk|done|rst_n|sdi|sdo|sh_en|start VSS
+ NND200
* cell instance $342 r0 *1 1355.4,429.8
X$342 \$I2762 clk|done|rst_n|sdi|sdo|sh_en|start
+ clk|done|rst_n|sdi|sdo|sh_en|start clk|done|rst_n|sdi|sdo|sh_en|start VSS
+ NND200
* cell instance $343 r0 *1 1273.5,1342.4
X$343 \$I6823 \$2042 clk|done|rst_n|sdi|sdo|sh_en|start
+ clk|done|rst_n|sdi|sdo|sh_en|start VSS NND200
* cell instance $344 r0 *1 1304.7,784.7
X$344 \$I2758 clk|done|rst_n|sdi|sdo|sh_en|start
+ clk|done|rst_n|sdi|sdo|sh_en|start clk|done|rst_n|sdi|sdo|sh_en|start VSS
+ NND200
* cell instance $345 r0 *1 1386.6,734
X$345 \$I2783 \$936 \$900 clk|done|rst_n|sdi|sdo|sh_en|start VSS NND200
* cell instance $346 r0 *1 1421.7,784.7
X$346 \$I2758 \$991 clk|done|rst_n|sdi|sdo|sh_en|start
+ clk|done|rst_n|sdi|sdo|sh_en|start VSS NND200
* cell instance $347 r0 *1 1078.5,1443.8
X$347 \$I6819 clk|done|rst_n|sdi|sdo|sh_en|start
+ clk|done|rst_n|sdi|sdo|sh_en|start clk|done|rst_n|sdi|sdo|sh_en|start VSS
+ NND200
* cell instance $348 r0 *1 1137,1443.8
X$348 \$I6819 clk|done|rst_n|sdi|sdo|sh_en|start
+ clk|done|rst_n|sdi|sdo|sh_en|start clk|done|rst_n|sdi|sdo|sh_en|start VSS
+ NND200
* cell instance $349 r0 *1 1480.2,734
X$349 \$I2783 clk|done|rst_n|sdi|sdo|sh_en|start
+ clk|done|rst_n|sdi|sdo|sh_en|start clk|done|rst_n|sdi|sdo|sh_en|start VSS
+ NND200
* cell instance $350 r0 *1 1125.3,987.5
X$350 \$I6725 clk|done|rst_n|sdi|sdo|sh_en|start
+ clk|done|rst_n|sdi|sdo|sh_en|start clk|done|rst_n|sdi|sdo|sh_en|start VSS
+ NND200
* cell instance $351 r0 *1 778.2,835.4
X$351 \$I6760 clk|done|rst_n|sdi|sdo|sh_en|start
+ clk|done|rst_n|sdi|sdo|sh_en|start clk|done|rst_n|sdi|sdo|sh_en|start VSS
+ NND200
* cell instance $352 r0 *1 1281.3,379.1
X$352 \$I2572 \$123 clk|done|rst_n|sdi|sdo|sh_en|start
+ clk|done|rst_n|sdi|sdo|sh_en|start VSS NND200
* cell instance $353 r0 *1 762.6,835.4
X$353 \$I6760 clk|done|rst_n|sdi|sdo|sh_en|start
+ clk|done|rst_n|sdi|sdo|sh_en|start clk|done|rst_n|sdi|sdo|sh_en|start VSS
+ NND200
* cell instance $354 r0 *1 1332,987.5
X$354 \$I6725 clk|done|rst_n|sdi|sdo|sh_en|start
+ clk|done|rst_n|sdi|sdo|sh_en|start clk|done|rst_n|sdi|sdo|sh_en|start VSS
+ NND200
* cell instance $355 r0 *1 1094.1,480.5
X$355 \$I2747 \$356 clk|done|rst_n|sdi|sdo|sh_en|start
+ clk|done|rst_n|sdi|sdo|sh_en|start VSS NND200
* cell instance $356 r0 *1 1012.2,1088.9
X$356 \$I6789 clk|done|rst_n|sdi|sdo|sh_en|start
+ clk|done|rst_n|sdi|sdo|sh_en|start clk|done|rst_n|sdi|sdo|sh_en|start VSS
+ NND200
* cell instance $357 r0 *1 1343.7,1342.4
X$357 \$I6823 clk|done|rst_n|sdi|sdo|sh_en|start
+ clk|done|rst_n|sdi|sdo|sh_en|start clk|done|rst_n|sdi|sdo|sh_en|start VSS
+ NND200
* cell instance $358 r0 *1 466.2,1190.3
X$358 \$I6808 clk|done|rst_n|sdi|sdo|sh_en|start
+ clk|done|rst_n|sdi|sdo|sh_en|start clk|done|rst_n|sdi|sdo|sh_en|start VSS
+ NND200
* cell instance $359 r0 *1 1051.2,1038.2
X$359 \$I6775 \$1511 clk|done|rst_n|sdi|sdo|sh_en|start
+ clk|done|rst_n|sdi|sdo|sh_en|start VSS NND200
* cell instance $360 r0 *1 532.5,886.1
X$360 \$I6796 clk|done|rst_n|sdi|sdo|sh_en|start
+ clk|done|rst_n|sdi|sdo|sh_en|start clk|done|rst_n|sdi|sdo|sh_en|start VSS
+ NND200
* cell instance $361 r0 *1 1074.6,835.4
X$361 \$I6760 clk|done|rst_n|sdi|sdo|sh_en|start
+ clk|done|rst_n|sdi|sdo|sh_en|start clk|done|rst_n|sdi|sdo|sh_en|start VSS
+ NND200
* cell instance $362 r0 *1 1121.4,835.4
X$362 \$I6760 \$1075 clk|done|rst_n|sdi|sdo|sh_en|start
+ clk|done|rst_n|sdi|sdo|sh_en|start VSS NND200
* cell instance $363 r0 *1 1078.5,1038.2
X$363 \$I6775 clk|done|rst_n|sdi|sdo|sh_en|start
+ clk|done|rst_n|sdi|sdo|sh_en|start clk|done|rst_n|sdi|sdo|sh_en|start VSS
+ NND200
* cell instance $364 r0 *1 1164.3,480.5
X$364 \$I2747 clk|done|rst_n|sdi|sdo|sh_en|start
+ clk|done|rst_n|sdi|sdo|sh_en|start clk|done|rst_n|sdi|sdo|sh_en|start VSS
+ NND200
* cell instance $365 r0 *1 953.7,784.7
X$365 \$I2758 clk|done|rst_n|sdi|sdo|sh_en|start
+ clk|done|rst_n|sdi|sdo|sh_en|start clk|done|rst_n|sdi|sdo|sh_en|start VSS
+ NND200
* cell instance $366 r0 *1 1445.1,987.5
X$366 \$I6725 clk|done|rst_n|sdi|sdo|sh_en|start \$1371
+ clk|done|rst_n|sdi|sdo|sh_en|start VSS NND200
* cell instance $367 r0 *1 1113.6,936.8
X$367 \$I6730 \$1247 clk|done|rst_n|sdi|sdo|sh_en|start
+ clk|done|rst_n|sdi|sdo|sh_en|start VSS NND200
* cell instance $368 r0 *1 1179.9,480.5
X$368 \$I2747 clk|done|rst_n|sdi|sdo|sh_en|start
+ clk|done|rst_n|sdi|sdo|sh_en|start clk|done|rst_n|sdi|sdo|sh_en|start VSS
+ NND200
* cell instance $369 r0 *1 1164.3,632.6
X$369 \$I6781 clk|done|rst_n|sdi|sdo|sh_en|start
+ clk|done|rst_n|sdi|sdo|sh_en|start clk|done|rst_n|sdi|sdo|sh_en|start VSS
+ NND200
* cell instance $370 r0 *1 1121.4,632.6
X$370 \$I6781 clk|done|rst_n|sdi|sdo|sh_en|start
+ clk|done|rst_n|sdi|sdo|sh_en|start clk|done|rst_n|sdi|sdo|sh_en|start VSS
+ NND200
* cell instance $371 r0 *1 1363.2,1241
X$371 \$I6818 clk|done|rst_n|sdi|sdo|sh_en|start
+ clk|done|rst_n|sdi|sdo|sh_en|start clk|done|rst_n|sdi|sdo|sh_en|start VSS
+ NND200
* cell instance $372 r0 *1 1140.9,429.8
X$372 \$I2762 clk|done|rst_n|sdi|sdo|sh_en|start
+ clk|done|rst_n|sdi|sdo|sh_en|start clk|done|rst_n|sdi|sdo|sh_en|start VSS
+ NND200
* cell instance $373 r0 *1 1062.9,632.6
X$373 \$I6781 clk|done|rst_n|sdi|sdo|sh_en|start
+ clk|done|rst_n|sdi|sdo|sh_en|start clk|done|rst_n|sdi|sdo|sh_en|start VSS
+ NND200
* cell instance $374 r0 *1 1597.2,632.6
X$374 \$I6781 clk|done|rst_n|sdi|sdo|sh_en|start
+ clk|done|rst_n|sdi|sdo|sh_en|start clk|done|rst_n|sdi|sdo|sh_en|start VSS
+ NND200
* cell instance $375 r0 *1 1125.3,429.8
X$375 \$I2762 \$185 clk|done|rst_n|sdi|sdo|sh_en|start
+ clk|done|rst_n|sdi|sdo|sh_en|start VSS NND200
* cell instance $376 r0 *1 1203.3,1393.1
X$376 \$I6830 clk|done|rst_n|sdi|sdo|sh_en|start
+ clk|done|rst_n|sdi|sdo|sh_en|start clk|done|rst_n|sdi|sdo|sh_en|start VSS
+ NND200
* cell instance $377 r0 *1 680.7,1088.9
X$377 \$I6789 clk|done|rst_n|sdi|sdo|sh_en|start
+ clk|done|rst_n|sdi|sdo|sh_en|start clk|done|rst_n|sdi|sdo|sh_en|start VSS
+ NND200
* cell instance $378 r0 *1 1460.7,987.5
X$378 \$I6725 clk|done|rst_n|sdi|sdo|sh_en|start
+ clk|done|rst_n|sdi|sdo|sh_en|start clk|done|rst_n|sdi|sdo|sh_en|start VSS
+ NND200
* cell instance $379 r0 *1 926.4,683.3
X$379 \$I6788 clk|done|rst_n|sdi|sdo|sh_en|start
+ clk|done|rst_n|sdi|sdo|sh_en|start clk|done|rst_n|sdi|sdo|sh_en|start VSS
+ NND200
* cell instance $380 r0 *1 540.3,531.2
X$380 \$I2745 clk|done|rst_n|sdi|sdo|sh_en|start \$435
+ clk|done|rst_n|sdi|sdo|sh_en|start VSS NND200
* cell instance $381 r0 *1 1246.2,1443.8
X$381 \$I6819 clk|done|rst_n|sdi|sdo|sh_en|start
+ clk|done|rst_n|sdi|sdo|sh_en|start clk|done|rst_n|sdi|sdo|sh_en|start VSS
+ NND200
* cell instance $382 r0 *1 1406.1,936.8
X$382 \$I6730 clk|done|rst_n|sdi|sdo|sh_en|start
+ clk|done|rst_n|sdi|sdo|sh_en|start clk|done|rst_n|sdi|sdo|sh_en|start VSS
+ NND200
* cell instance $383 r0 *1 1628.4,683.3
X$383 \$I6788 clk|done|rst_n|sdi|sdo|sh_en|start
+ clk|done|rst_n|sdi|sdo|sh_en|start clk|done|rst_n|sdi|sdo|sh_en|start VSS
+ NND200
* cell instance $384 r0 *1 665.1,1088.9
X$384 \$I6789 clk|done|rst_n|sdi|sdo|sh_en|start
+ clk|done|rst_n|sdi|sdo|sh_en|start clk|done|rst_n|sdi|sdo|sh_en|start VSS
+ NND200
* cell instance $385 r0 *1 867.9,632.6
X$385 \$I6781 clk|done|rst_n|sdi|sdo|sh_en|start
+ clk|done|rst_n|sdi|sdo|sh_en|start clk|done|rst_n|sdi|sdo|sh_en|start VSS
+ NND200
* cell instance $386 r0 *1 852.3,632.6
X$386 \$I6781 clk|done|rst_n|sdi|sdo|sh_en|start
+ clk|done|rst_n|sdi|sdo|sh_en|start clk|done|rst_n|sdi|sdo|sh_en|start VSS
+ NND200
* cell instance $387 r0 *1 1476.3,987.5
X$387 \$I6725 clk|done|rst_n|sdi|sdo|sh_en|start
+ clk|done|rst_n|sdi|sdo|sh_en|start clk|done|rst_n|sdi|sdo|sh_en|start VSS
+ NND200
* cell instance $388 r0 *1 969.3,683.3
X$388 \$I6788 \$771 clk|done|rst_n|sdi|sdo|sh_en|start
+ clk|done|rst_n|sdi|sdo|sh_en|start VSS NND200
* cell instance $389 r0 *1 860.1,886.1
X$389 \$I6796 clk|done|rst_n|sdi|sdo|sh_en|start
+ clk|done|rst_n|sdi|sdo|sh_en|start clk|done|rst_n|sdi|sdo|sh_en|start VSS
+ NND200
* cell instance $390 r0 *1 1402.2,1088.9
X$390 \$I6789 clk|done|rst_n|sdi|sdo|sh_en|start
+ clk|done|rst_n|sdi|sdo|sh_en|start clk|done|rst_n|sdi|sdo|sh_en|start VSS
+ NND200
* cell instance $391 r0 *1 856.2,1038.2
X$391 \$I6775 \$1505 clk|done|rst_n|sdi|sdo|sh_en|start
+ clk|done|rst_n|sdi|sdo|sh_en|start VSS NND200
* cell instance $392 r0 *1 1476.3,1393.1
X$392 \$I6830 \$2320 \$2174 clk|done|rst_n|sdi|sdo|sh_en|start VSS NND200
* cell instance $393 r0 *1 1390.5,936.8
X$393 \$I6730 clk|done|rst_n|sdi|sdo|sh_en|start
+ clk|done|rst_n|sdi|sdo|sh_en|start clk|done|rst_n|sdi|sdo|sh_en|start VSS
+ NND200
* cell instance $394 r0 *1 731.4,1595.9
X$394 \$I6827 clk|done|rst_n|sdi|sdo|sh_en|start
+ clk|done|rst_n|sdi|sdo|sh_en|start clk|done|rst_n|sdi|sdo|sh_en|start VSS
+ NND200
* cell instance $395 r0 *1 1413.9,1038.2
X$395 \$I6775 clk|done|rst_n|sdi|sdo|sh_en|start
+ clk|done|rst_n|sdi|sdo|sh_en|start clk|done|rst_n|sdi|sdo|sh_en|start VSS
+ NND200
* cell instance $396 r0 *1 930.3,1443.8
X$396 \$I6819 clk|done|rst_n|sdi|sdo|sh_en|start
+ clk|done|rst_n|sdi|sdo|sh_en|start clk|done|rst_n|sdi|sdo|sh_en|start VSS
+ NND200
* cell instance $397 r0 *1 867.9,936.8
X$397 \$I6730 \$1217 clk|done|rst_n|sdi|sdo|sh_en|start
+ clk|done|rst_n|sdi|sdo|sh_en|start VSS NND200
* cell instance $398 r0 *1 860.1,1443.8
X$398 \$I6819 clk|done|rst_n|sdi|sdo|sh_en|start
+ clk|done|rst_n|sdi|sdo|sh_en|start clk|done|rst_n|sdi|sdo|sh_en|start VSS
+ NND200
* cell instance $399 r0 *1 825,1393.1
X$399 \$I6830 \$2139 clk|done|rst_n|sdi|sdo|sh_en|start
+ clk|done|rst_n|sdi|sdo|sh_en|start VSS NND200
* cell instance $400 r0 *1 930.3,784.7
X$400 \$I2758 clk|done|rst_n|sdi|sdo|sh_en|start
+ clk|done|rst_n|sdi|sdo|sh_en|start clk|done|rst_n|sdi|sdo|sh_en|start VSS
+ NND200
* cell instance $401 r0 *1 1550.4,632.6
X$401 \$I6781 clk|done|rst_n|sdi|sdo|sh_en|start
+ clk|done|rst_n|sdi|sdo|sh_en|start clk|done|rst_n|sdi|sdo|sh_en|start VSS
+ NND200
* cell instance $402 r0 *1 739.2,734
X$402 \$I2783 clk|done|rst_n|sdi|sdo|sh_en|start \$882
+ clk|done|rst_n|sdi|sdo|sh_en|start VSS NND200
* cell instance $403 r0 *1 1066.8,531.2
X$403 \$I2745 clk|done|rst_n|sdi|sdo|sh_en|start
+ clk|done|rst_n|sdi|sdo|sh_en|start clk|done|rst_n|sdi|sdo|sh_en|start VSS
+ NND200
* cell instance $404 r0 *1 1320.3,1291.7
X$404 \$I6812 clk|done|rst_n|sdi|sdo|sh_en|start
+ clk|done|rst_n|sdi|sdo|sh_en|start clk|done|rst_n|sdi|sdo|sh_en|start VSS
+ NND200
* cell instance $405 r0 *1 708,1241
X$405 \$I6818 clk|done|rst_n|sdi|sdo|sh_en|start
+ clk|done|rst_n|sdi|sdo|sh_en|start clk|done|rst_n|sdi|sdo|sh_en|start VSS
+ NND200
* cell instance $406 r0 *1 1140.9,987.5
X$406 \$I6725 clk|done|rst_n|sdi|sdo|sh_en|start
+ clk|done|rst_n|sdi|sdo|sh_en|start clk|done|rst_n|sdi|sdo|sh_en|start VSS
+ NND200
* cell instance $407 r0 *1 1597.2,531.2
X$407 \$I2745 \$374 clk|done|rst_n|sdi|sdo|sh_en|start
+ clk|done|rst_n|sdi|sdo|sh_en|start VSS NND200
* cell instance $408 r0 *1 1222.8,1291.7
X$408 \$I6812 clk|done|rst_n|sdi|sdo|sh_en|start
+ clk|done|rst_n|sdi|sdo|sh_en|start clk|done|rst_n|sdi|sdo|sh_en|start VSS
+ NND200
* cell instance $409 r0 *1 825,1241
X$409 \$I6818 clk|done|rst_n|sdi|sdo|sh_en|start
+ clk|done|rst_n|sdi|sdo|sh_en|start clk|done|rst_n|sdi|sdo|sh_en|start VSS
+ NND200
* cell instance $410 r0 *1 1113.6,379.1
X$410 \$I2572 clk|done|rst_n|sdi|sdo|sh_en|start
+ clk|done|rst_n|sdi|sdo|sh_en|start clk|done|rst_n|sdi|sdo|sh_en|start VSS
+ NND200
* cell instance $411 r0 *1 1308.6,1595.9
X$411 \$I6827 clk|done|rst_n|sdi|sdo|sh_en|start
+ clk|done|rst_n|sdi|sdo|sh_en|start clk|done|rst_n|sdi|sdo|sh_en|start VSS
+ NND200
* cell instance $412 r0 *1 641.7,1038.2
X$412 \$I6775 clk|done|rst_n|sdi|sdo|sh_en|start \$1491
+ clk|done|rst_n|sdi|sdo|sh_en|start VSS NND200
* cell instance $413 r0 *1 887.4,835.4
X$413 \$I6760 clk|done|rst_n|sdi|sdo|sh_en|start
+ clk|done|rst_n|sdi|sdo|sh_en|start clk|done|rst_n|sdi|sdo|sh_en|start VSS
+ NND200
* cell instance $414 r0 *1 953.7,683.3
X$414 \$I6788 clk|done|rst_n|sdi|sdo|sh_en|start
+ clk|done|rst_n|sdi|sdo|sh_en|start clk|done|rst_n|sdi|sdo|sh_en|start VSS
+ NND200
* cell instance $415 r0 *1 1172.1,1291.7
X$415 \$I6812 clk|done|rst_n|sdi|sdo|sh_en|start
+ clk|done|rst_n|sdi|sdo|sh_en|start clk|done|rst_n|sdi|sdo|sh_en|start VSS
+ NND200
* cell instance $416 r0 *1 1593.3,1291.7
X$416 \$I6812 clk|done|rst_n|sdi|sdo|sh_en|start
+ clk|done|rst_n|sdi|sdo|sh_en|start \$2053 VSS NND200
* cell instance $417 r0 *1 1644,835.4
X$417 \$I6760 clk|done|rst_n|sdi|sdo|sh_en|start
+ clk|done|rst_n|sdi|sdo|sh_en|start \$1032 VSS NND200
* cell instance $418 r0 *1 1437.3,784.7
X$418 \$I2758 clk|done|rst_n|sdi|sdo|sh_en|start
+ clk|done|rst_n|sdi|sdo|sh_en|start \$991 VSS NND200
* cell instance $419 r0 *1 1445.1,683.3
X$419 \$I6788 clk|done|rst_n|sdi|sdo|sh_en|start \$795 \$698 VSS NND200
* cell instance $420 r0 *1 1359.3,1291.7
X$420 \$I6812 clk|done|rst_n|sdi|sdo|sh_en|start
+ clk|done|rst_n|sdi|sdo|sh_en|start clk|done|rst_n|sdi|sdo|sh_en|start
+ clk|done|rst_n|sdi|sdo|sh_en|start VSS ORND00
* cell instance $421 r0 *1 1413.9,1241
X$421 \$I6818 clk|done|rst_n|sdi|sdo|sh_en|start
+ clk|done|rst_n|sdi|sdo|sh_en|start clk|done|rst_n|sdi|sdo|sh_en|start
+ clk|done|rst_n|sdi|sdo|sh_en|start VSS ORND00
* cell instance $422 r0 *1 1355.4,1190.3
X$422 \$I6808 clk|done|rst_n|sdi|sdo|sh_en|start
+ clk|done|rst_n|sdi|sdo|sh_en|start clk|done|rst_n|sdi|sdo|sh_en|start
+ clk|done|rst_n|sdi|sdo|sh_en|start VSS ORND00
* cell instance $423 r0 *1 1640.1,1038.2
X$423 \$I6775 clk|done|rst_n|sdi|sdo|sh_en|start
+ clk|done|rst_n|sdi|sdo|sh_en|start clk|done|rst_n|sdi|sdo|sh_en|start
+ clk|done|rst_n|sdi|sdo|sh_en|start VSS ORND00
* cell instance $424 r0 *1 797.7,1342.4
X$424 \$I6823 clk|done|rst_n|sdi|sdo|sh_en|start
+ clk|done|rst_n|sdi|sdo|sh_en|start clk|done|rst_n|sdi|sdo|sh_en|start
+ clk|done|rst_n|sdi|sdo|sh_en|start VSS ORND00
* cell instance $425 r0 *1 1374.9,1088.9
X$425 \$I6789 clk|done|rst_n|sdi|sdo|sh_en|start
+ clk|done|rst_n|sdi|sdo|sh_en|start clk|done|rst_n|sdi|sdo|sh_en|start
+ clk|done|rst_n|sdi|sdo|sh_en|start VSS ORND00
* cell instance $426 r0 *1 641.7,1393.1
X$426 \$I6830 clk|done|rst_n|sdi|sdo|sh_en|start \$2131
+ clk|done|rst_n|sdi|sdo|sh_en|start clk|done|rst_n|sdi|sdo|sh_en|start VSS
+ ORND00
* cell instance $427 r0 *1 1195.5,379.1
X$427 \$I2572 clk|done|rst_n|sdi|sdo|sh_en|start
+ clk|done|rst_n|sdi|sdo|sh_en|start clk|done|rst_n|sdi|sdo|sh_en|start
+ clk|done|rst_n|sdi|sdo|sh_en|start VSS ORND00
* cell instance $428 r0 *1 934.2,1241
X$428 \$I6818 clk|done|rst_n|sdi|sdo|sh_en|start \$1849
+ clk|done|rst_n|sdi|sdo|sh_en|start clk|done|rst_n|sdi|sdo|sh_en|start VSS
+ ORND00
* cell instance $429 r0 *1 1410,1595.9
X$429 \$I6827 clk|done|rst_n|sdi|sdo|sh_en|start
+ clk|done|rst_n|sdi|sdo|sh_en|start clk|done|rst_n|sdi|sdo|sh_en|start
+ clk|done|rst_n|sdi|sdo|sh_en|start VSS ORND00
* cell instance $430 r0 *1 1445.1,1545.2
X$430 \$I6832 clk|done|rst_n|sdi|sdo|sh_en|start
+ clk|done|rst_n|sdi|sdo|sh_en|start clk|done|rst_n|sdi|sdo|sh_en|start
+ clk|done|rst_n|sdi|sdo|sh_en|start VSS ORND00
* cell instance $431 r0 *1 906.9,1443.8
X$431 \$I6819 clk|done|rst_n|sdi|sdo|sh_en|start \$2364
+ clk|done|rst_n|sdi|sdo|sh_en|start clk|done|rst_n|sdi|sdo|sh_en|start VSS
+ ORND00
* cell instance $432 r0 *1 879.6,581.9
X$432 \$I2828 \$555 clk|done|rst_n|sdi|sdo|sh_en|start
+ clk|done|rst_n|sdi|sdo|sh_en|start clk|done|rst_n|sdi|sdo|sh_en|start VSS
+ ORND00
* cell instance $433 r0 *1 1218.9,1342.4
X$433 \$I6823 clk|done|rst_n|sdi|sdo|sh_en|start
+ clk|done|rst_n|sdi|sdo|sh_en|start clk|done|rst_n|sdi|sdo|sh_en|start
+ clk|done|rst_n|sdi|sdo|sh_en|start VSS ORND00
* cell instance $434 r0 *1 1059,936.8
X$434 \$I6730 clk|done|rst_n|sdi|sdo|sh_en|start \$1296
+ clk|done|rst_n|sdi|sdo|sh_en|start \$1247 VSS ORND00
* cell instance $435 r0 *1 1277.4,936.8
X$435 \$I6730 clk|done|rst_n|sdi|sdo|sh_en|start
+ clk|done|rst_n|sdi|sdo|sh_en|start clk|done|rst_n|sdi|sdo|sh_en|start
+ clk|done|rst_n|sdi|sdo|sh_en|start VSS ORND00
* cell instance $436 r0 *1 1238.4,1291.7
X$436 \$I6812 clk|done|rst_n|sdi|sdo|sh_en|start
+ clk|done|rst_n|sdi|sdo|sh_en|start clk|done|rst_n|sdi|sdo|sh_en|start
+ clk|done|rst_n|sdi|sdo|sh_en|start VSS ORND00
* cell instance $437 r0 *1 653.4,632.6
X$437 \$I6781 clk|done|rst_n|sdi|sdo|sh_en|start
+ clk|done|rst_n|sdi|sdo|sh_en|start clk|done|rst_n|sdi|sdo|sh_en|start
+ clk|done|rst_n|sdi|sdo|sh_en|start VSS ORND00
* cell instance $438 r0 *1 848.4,1088.9
X$438 \$I6789 clk|done|rst_n|sdi|sdo|sh_en|start
+ clk|done|rst_n|sdi|sdo|sh_en|start clk|done|rst_n|sdi|sdo|sh_en|start
+ clk|done|rst_n|sdi|sdo|sh_en|start VSS ORND00
* cell instance $439 r0 *1 1273.5,1241
X$439 \$I6818 clk|done|rst_n|sdi|sdo|sh_en|start
+ clk|done|rst_n|sdi|sdo|sh_en|start clk|done|rst_n|sdi|sdo|sh_en|start
+ clk|done|rst_n|sdi|sdo|sh_en|start VSS ORND00
* cell instance $440 r0 *1 1035.6,1342.4
X$440 \$I6823 clk|done|rst_n|sdi|sdo|sh_en|start
+ clk|done|rst_n|sdi|sdo|sh_en|start clk|done|rst_n|sdi|sdo|sh_en|start
+ clk|done|rst_n|sdi|sdo|sh_en|start VSS ORND00
* cell instance $441 r0 *1 1289.1,1291.7
X$441 \$I6812 clk|done|rst_n|sdi|sdo|sh_en|start
+ clk|done|rst_n|sdi|sdo|sh_en|start clk|done|rst_n|sdi|sdo|sh_en|start
+ clk|done|rst_n|sdi|sdo|sh_en|start VSS ORND00
* cell instance $442 r0 *1 1246.2,734
X$442 \$I2783 clk|done|rst_n|sdi|sdo|sh_en|start
+ clk|done|rst_n|sdi|sdo|sh_en|start clk|done|rst_n|sdi|sdo|sh_en|start
+ clk|done|rst_n|sdi|sdo|sh_en|start VSS ORND00
* cell instance $443 r0 *1 1008.3,1443.8
X$443 \$I6819 clk|done|rst_n|sdi|sdo|sh_en|start
+ clk|done|rst_n|sdi|sdo|sh_en|start clk|done|rst_n|sdi|sdo|sh_en|start
+ clk|done|rst_n|sdi|sdo|sh_en|start VSS ORND00
* cell instance $444 r0 *1 1207.2,784.7
X$444 \$I2758 clk|done|rst_n|sdi|sdo|sh_en|start
+ clk|done|rst_n|sdi|sdo|sh_en|start clk|done|rst_n|sdi|sdo|sh_en|start
+ clk|done|rst_n|sdi|sdo|sh_en|start VSS ORND00
* cell instance $445 r0 *1 1644,1139.6
X$445 \$I6814 clk|done|rst_n|sdi|sdo|sh_en|start \$1723
+ clk|done|rst_n|sdi|sdo|sh_en|start clk|done|rst_n|sdi|sdo|sh_en|start VSS
+ ORND00
* cell instance $446 r0 *1 1250.1,936.8
X$446 \$I6730 clk|done|rst_n|sdi|sdo|sh_en|start
+ clk|done|rst_n|sdi|sdo|sh_en|start clk|done|rst_n|sdi|sdo|sh_en|start
+ clk|done|rst_n|sdi|sdo|sh_en|start VSS ORND00
* cell instance $447 r0 *1 1593.3,784.7
X$447 \$I2758 clk|done|rst_n|sdi|sdo|sh_en|start
+ clk|done|rst_n|sdi|sdo|sh_en|start clk|done|rst_n|sdi|sdo|sh_en|start
+ clk|done|rst_n|sdi|sdo|sh_en|start VSS ORND00
* cell instance $448 r0 *1 750.9,683.3
X$448 \$I6788 clk|done|rst_n|sdi|sdo|sh_en|start
+ clk|done|rst_n|sdi|sdo|sh_en|start clk|done|rst_n|sdi|sdo|sh_en|start
+ clk|done|rst_n|sdi|sdo|sh_en|start VSS ORND00
* cell instance $449 r0 *1 1168.2,1443.8
X$449 \$I6819 clk|done|rst_n|sdi|sdo|sh_en|start
+ clk|done|rst_n|sdi|sdo|sh_en|start clk|done|rst_n|sdi|sdo|sh_en|start \$2415
+ VSS ORND00
* cell instance $450 r0 *1 1605,835.4
X$450 \$I6760 clk|done|rst_n|sdi|sdo|sh_en|start \$1031
+ clk|done|rst_n|sdi|sdo|sh_en|start clk|done|rst_n|sdi|sdo|sh_en|start VSS
+ ORND00
* cell instance $451 r0 *1 1519.2,936.8
X$451 \$I6730 clk|done|rst_n|sdi|sdo|sh_en|start
+ clk|done|rst_n|sdi|sdo|sh_en|start clk|done|rst_n|sdi|sdo|sh_en|start \$1229
+ VSS ORND00
* cell instance $452 r0 *1 1324.2,835.4
X$452 \$I6760 clk|done|rst_n|sdi|sdo|sh_en|start
+ clk|done|rst_n|sdi|sdo|sh_en|start clk|done|rst_n|sdi|sdo|sh_en|start
+ clk|done|rst_n|sdi|sdo|sh_en|start VSS ORND00
* cell instance $453 r0 *1 1254,531.2
X$453 \$I2745 clk|done|rst_n|sdi|sdo|sh_en|start
+ clk|done|rst_n|sdi|sdo|sh_en|start clk|done|rst_n|sdi|sdo|sh_en|start
+ clk|done|rst_n|sdi|sdo|sh_en|start VSS ORND00
* cell instance $454 r0 *1 1140.9,632.6
X$454 \$I6781 clk|done|rst_n|sdi|sdo|sh_en|start
+ clk|done|rst_n|sdi|sdo|sh_en|start clk|done|rst_n|sdi|sdo|sh_en|start
+ clk|done|rst_n|sdi|sdo|sh_en|start VSS ORND00
* cell instance $455 r0 *1 1644,1241
X$455 \$I6818 clk|done|rst_n|sdi|sdo|sh_en|start
+ clk|done|rst_n|sdi|sdo|sh_en|start clk|done|rst_n|sdi|sdo|sh_en|start
+ clk|done|rst_n|sdi|sdo|sh_en|start VSS ORND00
* cell instance $456 r0 *1 1027.8,1595.9
X$456 \$I6827 clk|done|rst_n|sdi|sdo|sh_en|start
+ clk|done|rst_n|sdi|sdo|sh_en|start clk|done|rst_n|sdi|sdo|sh_en|start
+ clk|done|rst_n|sdi|sdo|sh_en|start VSS ORND00
* cell instance $457 r0 *1 836.7,1291.7
X$457 \$I6812 clk|done|rst_n|sdi|sdo|sh_en|start
+ clk|done|rst_n|sdi|sdo|sh_en|start clk|done|rst_n|sdi|sdo|sh_en|start
+ clk|done|rst_n|sdi|sdo|sh_en|start VSS ORND00
* cell instance $458 r0 *1 1179.9,987.5
X$458 \$I6725 clk|done|rst_n|sdi|sdo|sh_en|start
+ clk|done|rst_n|sdi|sdo|sh_en|start clk|done|rst_n|sdi|sdo|sh_en|start
+ clk|done|rst_n|sdi|sdo|sh_en|start VSS ORND00
* cell instance $459 r0 *1 1218.9,987.5
X$459 \$I6725 clk|done|rst_n|sdi|sdo|sh_en|start
+ clk|done|rst_n|sdi|sdo|sh_en|start clk|done|rst_n|sdi|sdo|sh_en|start
+ clk|done|rst_n|sdi|sdo|sh_en|start VSS ORND00
* cell instance $460 r0 *1 1347.6,987.5
X$460 \$I6725 clk|done|rst_n|sdi|sdo|sh_en|start
+ clk|done|rst_n|sdi|sdo|sh_en|start clk|done|rst_n|sdi|sdo|sh_en|start
+ clk|done|rst_n|sdi|sdo|sh_en|start VSS ORND00
* cell instance $461 r0 *1 1156.5,987.5
X$461 \$I6725 clk|done|rst_n|sdi|sdo|sh_en|start
+ clk|done|rst_n|sdi|sdo|sh_en|start clk|done|rst_n|sdi|sdo|sh_en|start
+ clk|done|rst_n|sdi|sdo|sh_en|start VSS ORND00
* cell instance $462 r0 *1 1605,480.5
X$462 \$I2747 clk|done|rst_n|sdi|sdo|sh_en|start \$376 \$375 \$374 VSS ORND00
* cell instance $463 r0 *1 805.5,1545.2
X$463 \$I6832 clk|done|rst_n|sdi|sdo|sh_en|start
+ clk|done|rst_n|sdi|sdo|sh_en|start \$2646 clk|done|rst_n|sdi|sdo|sh_en|start
+ VSS ORND00
* cell instance $464 r0 *1 1507.5,1393.1
X$464 \$I6830 clk|done|rst_n|sdi|sdo|sh_en|start
+ clk|done|rst_n|sdi|sdo|sh_en|start \$2220 clk|done|rst_n|sdi|sdo|sh_en|start
+ VSS ORND00
* cell instance $465 r0 *1 649.5,1342.4
X$465 \$I6823 clk|done|rst_n|sdi|sdo|sh_en|start
+ clk|done|rst_n|sdi|sdo|sh_en|start \$2131 clk|done|rst_n|sdi|sdo|sh_en|start
+ VSS ORND00
* cell instance $466 r0 *1 1390.5,1038.2
X$466 \$I6775 clk|done|rst_n|sdi|sdo|sh_en|start
+ clk|done|rst_n|sdi|sdo|sh_en|start \$1519 clk|done|rst_n|sdi|sdo|sh_en|start
+ VSS ORND00
* cell instance $467 r0 *1 1605,683.3
X$467 \$I6788 clk|done|rst_n|sdi|sdo|sh_en|start
+ clk|done|rst_n|sdi|sdo|sh_en|start \$707 clk|done|rst_n|sdi|sdo|sh_en|start
+ VSS ORND00
* cell instance $468 r0 *1 1503.6,1291.7
X$468 \$I6812 clk|done|rst_n|sdi|sdo|sh_en|start
+ clk|done|rst_n|sdi|sdo|sh_en|start \$2053 clk|done|rst_n|sdi|sdo|sh_en|start
+ VSS ORND00
* cell instance $469 r0 *1 1090.2,379.1
X$469 \$I2572 clk|done|rst_n|sdi|sdo|sh_en|start \$83 \$115
+ clk|done|rst_n|sdi|sdo|sh_en|start VSS ORND00
* cell instance $470 r0 *1 1378.8,379.1
X$470 \$I2572 clk|done|rst_n|sdi|sdo|sh_en|start
+ clk|done|rst_n|sdi|sdo|sh_en|start \$128 clk|done|rst_n|sdi|sdo|sh_en|start
+ VSS ORND00
* cell instance $471 r0 *1 1359.3,379.1
X$471 \$I2572 clk|done|rst_n|sdi|sdo|sh_en|start \$125
+ clk|done|rst_n|sdi|sdo|sh_en|start VSS NOR200
* cell instance $472 r0 *1 809.4,1241
X$472 \$I6818 clk|done|rst_n|sdi|sdo|sh_en|start
+ clk|done|rst_n|sdi|sdo|sh_en|start clk|done|rst_n|sdi|sdo|sh_en|start VSS
+ NOR200
* cell instance $473 r0 *1 1374.9,531.2
X$473 \$I2745 clk|done|rst_n|sdi|sdo|sh_en|start
+ clk|done|rst_n|sdi|sdo|sh_en|start clk|done|rst_n|sdi|sdo|sh_en|start VSS
+ NOR200
* cell instance $474 r0 *1 739.2,1190.3
X$474 \$I6808 clk|done|rst_n|sdi|sdo|sh_en|start
+ clk|done|rst_n|sdi|sdo|sh_en|start clk|done|rst_n|sdi|sdo|sh_en|start VSS
+ NOR200
* cell instance $475 r0 *1 1347.6,835.4
X$475 \$I6760 clk|done|rst_n|sdi|sdo|sh_en|start
+ clk|done|rst_n|sdi|sdo|sh_en|start \$1115 VSS NOR200
* cell instance $476 r0 *1 1628.4,835.4
X$476 \$I6760 clk|done|rst_n|sdi|sdo|sh_en|start
+ clk|done|rst_n|sdi|sdo|sh_en|start clk|done|rst_n|sdi|sdo|sh_en|start VSS
+ NOR200
* cell instance $477 r0 *1 1480.2,1241
X$477 \$I6818 clk|done|rst_n|sdi|sdo|sh_en|start
+ clk|done|rst_n|sdi|sdo|sh_en|start clk|done|rst_n|sdi|sdo|sh_en|start VSS
+ NOR200
* cell instance $478 r0 *1 1140.9,1088.9
X$478 \$I6789 clk|done|rst_n|sdi|sdo|sh_en|start
+ clk|done|rst_n|sdi|sdo|sh_en|start clk|done|rst_n|sdi|sdo|sh_en|start VSS
+ NOR200
* cell instance $479 r0 *1 704.1,1545.2
X$479 \$I6832 clk|done|rst_n|sdi|sdo|sh_en|start
+ clk|done|rst_n|sdi|sdo|sh_en|start clk|done|rst_n|sdi|sdo|sh_en|start VSS
+ NOR200
* cell instance $480 r0 *1 1593.3,1088.9
X$480 \$I6789 clk|done|rst_n|sdi|sdo|sh_en|start
+ clk|done|rst_n|sdi|sdo|sh_en|start clk|done|rst_n|sdi|sdo|sh_en|start VSS
+ NOR200
* cell instance $481 r0 *1 1374.9,581.9
X$481 \$I2828 clk|done|rst_n|sdi|sdo|sh_en|start \$508
+ clk|done|rst_n|sdi|sdo|sh_en|start VSS NOR200
* cell instance $482 r0 *1 1207.2,1443.8
X$482 \$I6819 clk|done|rst_n|sdi|sdo|sh_en|start
+ clk|done|rst_n|sdi|sdo|sh_en|start clk|done|rst_n|sdi|sdo|sh_en|start VSS
+ NOR200
* cell instance $483 r0 *1 1176,835.4
X$483 \$I6760 clk|done|rst_n|sdi|sdo|sh_en|start
+ clk|done|rst_n|sdi|sdo|sh_en|start clk|done|rst_n|sdi|sdo|sh_en|start VSS
+ NOR200
* cell instance $484 r0 *1 672.9,1342.4
X$484 \$I6823 clk|done|rst_n|sdi|sdo|sh_en|start
+ clk|done|rst_n|sdi|sdo|sh_en|start clk|done|rst_n|sdi|sdo|sh_en|start VSS
+ NOR200
* cell instance $485 r0 *1 1191.6,1443.8
X$485 \$I6819 clk|done|rst_n|sdi|sdo|sh_en|start
+ clk|done|rst_n|sdi|sdo|sh_en|start clk|done|rst_n|sdi|sdo|sh_en|start VSS
+ NOR200
* cell instance $486 r0 *1 1363.2,1443.8
X$486 \$I6819 clk|done|rst_n|sdi|sdo|sh_en|start
+ clk|done|rst_n|sdi|sdo|sh_en|start clk|done|rst_n|sdi|sdo|sh_en|start VSS
+ NOR200
* cell instance $487 r0 *1 1176,1393.1
X$487 \$I6830 clk|done|rst_n|sdi|sdo|sh_en|start
+ clk|done|rst_n|sdi|sdo|sh_en|start clk|done|rst_n|sdi|sdo|sh_en|start VSS
+ NOR200
* cell instance $488 r0 *1 1004.4,1038.2
X$488 \$I6775 clk|done|rst_n|sdi|sdo|sh_en|start \$1472
+ clk|done|rst_n|sdi|sdo|sh_en|start VSS NOR200
* cell instance $489 r0 *1 1347.6,1241
X$489 \$I6818 clk|done|rst_n|sdi|sdo|sh_en|start
+ clk|done|rst_n|sdi|sdo|sh_en|start clk|done|rst_n|sdi|sdo|sh_en|start VSS
+ NOR200
* cell instance $490 r0 *1 1577.7,1088.9
X$490 \$I6789 clk|done|rst_n|sdi|sdo|sh_en|start
+ clk|done|rst_n|sdi|sdo|sh_en|start clk|done|rst_n|sdi|sdo|sh_en|start VSS
+ NOR200
* cell instance $491 r0 *1 871.8,1038.2
X$491 \$I6775 clk|done|rst_n|sdi|sdo|sh_en|start
+ clk|done|rst_n|sdi|sdo|sh_en|start clk|done|rst_n|sdi|sdo|sh_en|start VSS
+ NOR200
* cell instance $492 r0 *1 1371,936.8
X$492 \$I6730 clk|done|rst_n|sdi|sdo|sh_en|start
+ clk|done|rst_n|sdi|sdo|sh_en|start clk|done|rst_n|sdi|sdo|sh_en|start VSS
+ NOR200
* cell instance $493 r0 *1 758.7,1190.3
X$493 \$I6808 clk|done|rst_n|sdi|sdo|sh_en|start
+ clk|done|rst_n|sdi|sdo|sh_en|start clk|done|rst_n|sdi|sdo|sh_en|start VSS
+ NOR200
* cell instance $494 r0 *1 1207.2,1291.7
X$494 \$I6812 clk|done|rst_n|sdi|sdo|sh_en|start
+ clk|done|rst_n|sdi|sdo|sh_en|start clk|done|rst_n|sdi|sdo|sh_en|start VSS
+ NOR200
* cell instance $495 r0 *1 1410,1393.1
X$495 \$I6830 clk|done|rst_n|sdi|sdo|sh_en|start
+ clk|done|rst_n|sdi|sdo|sh_en|start clk|done|rst_n|sdi|sdo|sh_en|start VSS
+ NOR200
* cell instance $496 r0 *1 840.6,1190.3
X$496 \$I6808 clk|done|rst_n|sdi|sdo|sh_en|start
+ clk|done|rst_n|sdi|sdo|sh_en|start clk|done|rst_n|sdi|sdo|sh_en|start VSS
+ NOR200
* cell instance $497 r0 *1 1156.5,886.1
X$497 \$I6796 clk|done|rst_n|sdi|sdo|sh_en|start
+ clk|done|rst_n|sdi|sdo|sh_en|start clk|done|rst_n|sdi|sdo|sh_en|start VSS
+ NOR200
* cell instance $498 r0 *1 1168.2,936.8
X$498 \$I6730 clk|done|rst_n|sdi|sdo|sh_en|start
+ clk|done|rst_n|sdi|sdo|sh_en|start clk|done|rst_n|sdi|sdo|sh_en|start VSS
+ NOR200
* cell instance $499 r0 *1 1491.9,1393.1
X$499 \$I6830 clk|done|rst_n|sdi|sdo|sh_en|start
+ clk|done|rst_n|sdi|sdo|sh_en|start clk|done|rst_n|sdi|sdo|sh_en|start VSS
+ NOR200
* cell instance $500 r0 *1 1285.2,632.6
X$500 \$I6781 clk|done|rst_n|sdi|sdo|sh_en|start
+ clk|done|rst_n|sdi|sdo|sh_en|start clk|done|rst_n|sdi|sdo|sh_en|start VSS
+ NOR200
* cell instance $501 r0 *1 984.9,1038.2
X$501 \$I6775 clk|done|rst_n|sdi|sdo|sh_en|start
+ clk|done|rst_n|sdi|sdo|sh_en|start clk|done|rst_n|sdi|sdo|sh_en|start VSS
+ NOR200
* cell instance $502 r0 *1 1390.5,531.2
X$502 \$I2745 clk|done|rst_n|sdi|sdo|sh_en|start
+ clk|done|rst_n|sdi|sdo|sh_en|start clk|done|rst_n|sdi|sdo|sh_en|start VSS
+ NOR200
* cell instance $503 r0 *1 1620.6,581.9
X$503 \$I2828 clk|done|rst_n|sdi|sdo|sh_en|start \$516
+ clk|done|rst_n|sdi|sdo|sh_en|start VSS NOR200
* cell instance $504 r0 *1 1246.2,886.1
X$504 \$I6796 clk|done|rst_n|sdi|sdo|sh_en|start
+ clk|done|rst_n|sdi|sdo|sh_en|start clk|done|rst_n|sdi|sdo|sh_en|start VSS
+ NOR200
* cell instance $505 r0 *1 552,1190.3
X$505 \$I6808 clk|done|rst_n|sdi|sdo|sh_en|start
+ clk|done|rst_n|sdi|sdo|sh_en|start clk|done|rst_n|sdi|sdo|sh_en|start VSS
+ NOR200
* cell instance $506 r0 *1 887.4,1545.2
X$506 \$I6832 clk|done|rst_n|sdi|sdo|sh_en|start
+ clk|done|rst_n|sdi|sdo|sh_en|start clk|done|rst_n|sdi|sdo|sh_en|start VSS
+ NOR200
* cell instance $507 r0 *1 1304.7,480.5
X$507 \$I2747 clk|done|rst_n|sdi|sdo|sh_en|start
+ clk|done|rst_n|sdi|sdo|sh_en|start clk|done|rst_n|sdi|sdo|sh_en|start VSS
+ NOR200
* cell instance $508 r0 *1 1476.3,1443.8
X$508 \$I6819 clk|done|rst_n|sdi|sdo|sh_en|start
+ clk|done|rst_n|sdi|sdo|sh_en|start clk|done|rst_n|sdi|sdo|sh_en|start VSS
+ NOR200
* cell instance $509 r0 *1 1355.4,1088.9
X$509 \$I6789 clk|done|rst_n|sdi|sdo|sh_en|start \$1519
+ clk|done|rst_n|sdi|sdo|sh_en|start VSS NOR200
* cell instance $510 r0 *1 1140.9,480.5
X$510 \$I2747 clk|done|rst_n|sdi|sdo|sh_en|start
+ clk|done|rst_n|sdi|sdo|sh_en|start \$393 VSS NOR200
* cell instance $511 r0 *1 1347.6,1393.1
X$511 \$I6830 clk|done|rst_n|sdi|sdo|sh_en|start
+ clk|done|rst_n|sdi|sdo|sh_en|start clk|done|rst_n|sdi|sdo|sh_en|start VSS
+ NOR200
* cell instance $512 r0 *1 532.5,1139.6
X$512 \$I6814 clk|done|rst_n|sdi|sdo|sh_en|start
+ clk|done|rst_n|sdi|sdo|sh_en|start clk|done|rst_n|sdi|sdo|sh_en|start VSS
+ NOR200
* cell instance $513 r0 *1 1289.1,480.5
X$513 \$I2747 clk|done|rst_n|sdi|sdo|sh_en|start
+ clk|done|rst_n|sdi|sdo|sh_en|start clk|done|rst_n|sdi|sdo|sh_en|start VSS
+ NOR200
* cell instance $514 r0 *1 1285.2,1595.9
X$514 \$I6827 clk|done|rst_n|sdi|sdo|sh_en|start
+ clk|done|rst_n|sdi|sdo|sh_en|start clk|done|rst_n|sdi|sdo|sh_en|start VSS
+ NOR200
* cell instance $515 r0 *1 1211.1,1595.9
X$515 \$I6827 clk|done|rst_n|sdi|sdo|sh_en|start
+ clk|done|rst_n|sdi|sdo|sh_en|start clk|done|rst_n|sdi|sdo|sh_en|start VSS
+ NOR200
* cell instance $516 r0 *1 1562.1,1545.2
X$516 \$I6832 clk|done|rst_n|sdi|sdo|sh_en|start
+ clk|done|rst_n|sdi|sdo|sh_en|start clk|done|rst_n|sdi|sdo|sh_en|start VSS
+ NOR200
* cell instance $517 r0 *1 1187.7,1291.7
X$517 \$I6812 clk|done|rst_n|sdi|sdo|sh_en|start
+ clk|done|rst_n|sdi|sdo|sh_en|start clk|done|rst_n|sdi|sdo|sh_en|start VSS
+ NOR200
* cell instance $518 r0 *1 1394.4,1393.1
X$518 \$I6830 clk|done|rst_n|sdi|sdo|sh_en|start
+ clk|done|rst_n|sdi|sdo|sh_en|start clk|done|rst_n|sdi|sdo|sh_en|start VSS
+ NOR200
* cell instance $519 r0 *1 1059,1291.7
X$519 \$I6812 clk|done|rst_n|sdi|sdo|sh_en|start
+ clk|done|rst_n|sdi|sdo|sh_en|start clk|done|rst_n|sdi|sdo|sh_en|start VSS
+ NOR200
* cell instance $520 r0 *1 844.5,987.5
X$520 \$I6725 clk|done|rst_n|sdi|sdo|sh_en|start
+ clk|done|rst_n|sdi|sdo|sh_en|start clk|done|rst_n|sdi|sdo|sh_en|start VSS
+ NOR200
* cell instance $521 r0 *1 454.5,734
X$521 \$I2783 clk|done|rst_n|sdi|sdo|sh_en|start
+ clk|done|rst_n|sdi|sdo|sh_en|start clk|done|rst_n|sdi|sdo|sh_en|start VSS
+ NOR200
* cell instance $522 r0 *1 1086.3,1139.6
X$522 \$I6814 clk|done|rst_n|sdi|sdo|sh_en|start
+ clk|done|rst_n|sdi|sdo|sh_en|start clk|done|rst_n|sdi|sdo|sh_en|start VSS
+ NOR200
* cell instance $523 r0 *1 587.1,1291.7
X$523 \$I6812 clk|done|rst_n|sdi|sdo|sh_en|start
+ clk|done|rst_n|sdi|sdo|sh_en|start clk|done|rst_n|sdi|sdo|sh_en|start VSS
+ NOR200
* cell instance $524 r0 *1 1371,1139.6
X$524 \$I6814 clk|done|rst_n|sdi|sdo|sh_en|start \$1655
+ clk|done|rst_n|sdi|sdo|sh_en|start VSS NOR200
* cell instance $525 r0 *1 1542.6,379.1
X$525 \$I2572 clk|done|rst_n|sdi|sdo|sh_en|start
+ clk|done|rst_n|sdi|sdo|sh_en|start clk|done|rst_n|sdi|sdo|sh_en|start VSS
+ NOR200
* cell instance $526 r0 *1 1242.3,987.5
X$526 \$I6725 clk|done|rst_n|sdi|sdo|sh_en|start
+ clk|done|rst_n|sdi|sdo|sh_en|start clk|done|rst_n|sdi|sdo|sh_en|start VSS
+ NOR200
* cell instance $527 r0 *1 1484.1,1494.5
X$527 \$I6833 clk|done|rst_n|sdi|sdo|sh_en|start
+ clk|done|rst_n|sdi|sdo|sh_en|start clk|done|rst_n|sdi|sdo|sh_en|start VSS
+ NOR200
* cell instance $528 r0 *1 1484.1,1088.9
X$528 \$I6789 clk|done|rst_n|sdi|sdo|sh_en|start
+ clk|done|rst_n|sdi|sdo|sh_en|start clk|done|rst_n|sdi|sdo|sh_en|start VSS
+ NOR200
* cell instance $529 r0 *1 1234.5,1088.9
X$529 \$I6789 clk|done|rst_n|sdi|sdo|sh_en|start
+ clk|done|rst_n|sdi|sdo|sh_en|start clk|done|rst_n|sdi|sdo|sh_en|start VSS
+ NOR200
* cell instance $530 r0 *1 1585.5,1443.8
X$530 \$I6819 clk|done|rst_n|sdi|sdo|sh_en|start \$2429
+ clk|done|rst_n|sdi|sdo|sh_en|start VSS NOR200
* cell instance $531 r0 *1 1043.4,1241
X$531 \$I6818 clk|done|rst_n|sdi|sdo|sh_en|start
+ clk|done|rst_n|sdi|sdo|sh_en|start clk|done|rst_n|sdi|sdo|sh_en|start VSS
+ NOR200
* cell instance $532 r0 *1 1148.7,1038.2
X$532 \$I6775 clk|done|rst_n|sdi|sdo|sh_en|start \$1515
+ clk|done|rst_n|sdi|sdo|sh_en|start VSS NOR200
* cell instance $533 r0 *1 786,1443.8
X$533 \$I6819 clk|done|rst_n|sdi|sdo|sh_en|start
+ clk|done|rst_n|sdi|sdo|sh_en|start clk|done|rst_n|sdi|sdo|sh_en|start VSS
+ NOR200
* cell instance $534 r0 *1 1515.3,987.5
X$534 \$I6725 clk|done|rst_n|sdi|sdo|sh_en|start \$1374
+ clk|done|rst_n|sdi|sdo|sh_en|start VSS NOR200
* cell instance $535 r0 *1 1218.9,1088.9
X$535 \$I6789 clk|done|rst_n|sdi|sdo|sh_en|start
+ clk|done|rst_n|sdi|sdo|sh_en|start clk|done|rst_n|sdi|sdo|sh_en|start VSS
+ NOR200
* cell instance $536 r0 *1 981,531.2
X$536 \$I2745 \$426 clk|done|rst_n|sdi|sdo|sh_en|start
+ clk|done|rst_n|sdi|sdo|sh_en|start VSS NOR200
* cell instance $537 r0 *1 1090.2,1088.9
X$537 \$I6789 \$1645 clk|done|rst_n|sdi|sdo|sh_en|start
+ clk|done|rst_n|sdi|sdo|sh_en|start VSS NOR200
* cell instance $538 r0 *1 1534.8,1088.9
X$538 \$I6789 \$1605 \$1532 clk|done|rst_n|sdi|sdo|sh_en|start VSS NOR200
* cell instance $539 r0 *1 1363.2,835.4
X$539 \$I6760 \$1115 clk|done|rst_n|sdi|sdo|sh_en|start
+ clk|done|rst_n|sdi|sdo|sh_en|start VSS NOR200
* cell instance $540 r0 *1 669,1545.2
X$540 \$I6832 \$2642 clk|done|rst_n|sdi|sdo|sh_en|start
+ clk|done|rst_n|sdi|sdo|sh_en|start VSS NOR200
* cell instance $541 r0 *1 1133.1,1038.2
X$541 \$I6775 \$1515 clk|done|rst_n|sdi|sdo|sh_en|start
+ clk|done|rst_n|sdi|sdo|sh_en|start VSS NOR200
* cell instance $542 r0 *1 1000.5,379.1
X$542 \$I2572 \$154 \$87 clk|done|rst_n|sdi|sdo|sh_en|start VSS NOR200
* cell instance $543 r0 *1 1546.5,480.5
X$543 \$I2747 \$318 clk|done|rst_n|sdi|sdo|sh_en|start
+ clk|done|rst_n|sdi|sdo|sh_en|start VSS NOR200
* cell instance $544 r0 *1 1265.7,835.4
X$544 \$I6760 \$1082 clk|done|rst_n|sdi|sdo|sh_en|start
+ clk|done|rst_n|sdi|sdo|sh_en|start VSS NOR200
* cell instance $545 r0 *1 1527,734
X$545 \$I2783 \$845 clk|done|rst_n|sdi|sdo|sh_en|start
+ clk|done|rst_n|sdi|sdo|sh_en|start VSS NOR200
* cell instance $546 r0 *1 1129.2,1291.7
X$546 \$I6812 \$2074 clk|done|rst_n|sdi|sdo|sh_en|start
+ clk|done|rst_n|sdi|sdo|sh_en|start VSS NOR200
* cell instance $547 r0 *1 1082.4,683.3
X$547 \$I6788 \$774 \$775 clk|done|rst_n|sdi|sdo|sh_en|start VSS NOR200
* cell instance $548 r0 *1 1261.8,886.1
X$548 \$I6796 \$1084 clk|done|rst_n|sdi|sdo|sh_en|start
+ clk|done|rst_n|sdi|sdo|sh_en|start VSS NOR200
* cell instance $549 r0 *1 754.8,1443.8
X$549 \$I6819 \$2448 \$2390 clk|done|rst_n|sdi|sdo|sh_en|start VSS NOR200
* cell instance $550 r0 *1 739.2,1443.8
X$550 \$I6819 \$2390 clk|done|rst_n|sdi|sdo|sh_en|start
+ clk|done|rst_n|sdi|sdo|sh_en|start VSS NOR200
* cell instance $551 r0 *1 1176,1190.3
X$551 \$I6808 \$1857 clk|done|rst_n|sdi|sdo|sh_en|start
+ clk|done|rst_n|sdi|sdo|sh_en|start VSS NOR200
* cell instance $552 r0 *1 1261.8,1595.9
X$552 \$I6827 \$2735 clk|done|rst_n|sdi|sdo|sh_en|start
+ clk|done|rst_n|sdi|sdo|sh_en|start VSS NOR200
* cell instance $553 r0 *1 1417.8,1088.9
X$553 \$I6789 \$1654 clk|done|rst_n|sdi|sdo|sh_en|start
+ clk|done|rst_n|sdi|sdo|sh_en|start VSS NOR200
* cell instance $554 r0 *1 1437.3,1595.9
X$554 \$I6827 \$2741 clk|done|rst_n|sdi|sdo|sh_en|start
+ clk|done|rst_n|sdi|sdo|sh_en|start VSS NOR200
* cell instance $555 r0 *1 1121.4,1443.8
X$555 \$I6819 \$2284 clk|done|rst_n|sdi|sdo|sh_en|start
+ clk|done|rst_n|sdi|sdo|sh_en|start VSS NOR200
* cell instance $556 r0 *1 1101.9,1139.6
X$556 \$I6814 \$1770 clk|done|rst_n|sdi|sdo|sh_en|start
+ clk|done|rst_n|sdi|sdo|sh_en|start VSS NOR200
* cell instance $557 r0 *1 1324.2,1595.9
X$557 \$I6827 \$2694 clk|done|rst_n|sdi|sdo|sh_en|start
+ clk|done|rst_n|sdi|sdo|sh_en|start VSS NOR200
* cell instance $558 r0 *1 1051.2,1595.9
X$558 \$I6827 \$2608 clk|done|rst_n|sdi|sdo|sh_en|start \$2728 VSS NOR200
* cell instance $559 r0 *1 789.9,480.5
X$559 clk|done|rst_n|sdi|sdo|sh_en|start clk|done|rst_n|sdi|sdo|sh_en|start
+ clk|done|rst_n|sdi|sdo|sh_en|start clk|done|rst_n|sdi|sdo|sh_en|start \$I2747
+ VSS MX2100
* cell instance $560 r0 *1 1156.5,683.3
X$560 clk|done|rst_n|sdi|sdo|sh_en|start clk|done|rst_n|sdi|sdo|sh_en|start
+ clk|done|rst_n|sdi|sdo|sh_en|start clk|done|rst_n|sdi|sdo|sh_en|start \$I6788
+ VSS MX2100
* cell instance $561 r0 *1 1573.8,987.5
X$561 clk|done|rst_n|sdi|sdo|sh_en|start clk|done|rst_n|sdi|sdo|sh_en|start
+ clk|done|rst_n|sdi|sdo|sh_en|start clk|done|rst_n|sdi|sdo|sh_en|start \$I6725
+ VSS MX2100
* cell instance $562 r0 *1 719.7,480.5
X$562 clk|done|rst_n|sdi|sdo|sh_en|start clk|done|rst_n|sdi|sdo|sh_en|start
+ clk|done|rst_n|sdi|sdo|sh_en|start clk|done|rst_n|sdi|sdo|sh_en|start \$I2747
+ VSS MX2100
* cell instance $563 r0 *1 735.3,581.9
X$563 clk|done|rst_n|sdi|sdo|sh_en|start clk|done|rst_n|sdi|sdo|sh_en|start
+ clk|done|rst_n|sdi|sdo|sh_en|start clk|done|rst_n|sdi|sdo|sh_en|start \$I2828
+ VSS MX2100
* cell instance $564 r0 *1 618.3,429.8
X$564 clk|done|rst_n|sdi|sdo|sh_en|start clk|done|rst_n|sdi|sdo|sh_en|start
+ clk|done|rst_n|sdi|sdo|sh_en|start clk|done|rst_n|sdi|sdo|sh_en|start \$I2762
+ VSS MX2100
* cell instance $565 r0 *1 626.1,784.7
X$565 \$882 clk|done|rst_n|sdi|sdo|sh_en|start
+ clk|done|rst_n|sdi|sdo|sh_en|start clk|done|rst_n|sdi|sdo|sh_en|start \$I2758
+ VSS MX2100
* cell instance $566 r0 *1 1195.5,480.5
X$566 \$251 clk|done|rst_n|sdi|sdo|sh_en|start
+ clk|done|rst_n|sdi|sdo|sh_en|start clk|done|rst_n|sdi|sdo|sh_en|start \$I2747
+ VSS MX2100
* cell instance $567 r0 *1 649.5,429.8
X$567 clk|done|rst_n|sdi|sdo|sh_en|start clk|done|rst_n|sdi|sdo|sh_en|start
+ clk|done|rst_n|sdi|sdo|sh_en|start clk|done|rst_n|sdi|sdo|sh_en|start \$I2762
+ VSS MX2100
* cell instance $568 r0 *1 770.4,632.6
X$568 clk|done|rst_n|sdi|sdo|sh_en|start clk|done|rst_n|sdi|sdo|sh_en|start
+ clk|done|rst_n|sdi|sdo|sh_en|start clk|done|rst_n|sdi|sdo|sh_en|start \$I6781
+ VSS MX2100
* cell instance $569 r0 *1 1566,531.2
X$569 \$375 clk|done|rst_n|sdi|sdo|sh_en|start
+ clk|done|rst_n|sdi|sdo|sh_en|start clk|done|rst_n|sdi|sdo|sh_en|start \$I2745
+ VSS MX2100
* cell instance $570 r0 *1 353.1,1139.6
X$570 \$1692 \$1623 clk|done|rst_n|sdi|sdo|sh_en|start
+ clk|done|rst_n|sdi|sdo|sh_en|start \$I6814 VSS MX2100
* cell instance $571 r0 *1 1090.2,784.7
X$571 \$775 clk|done|rst_n|sdi|sdo|sh_en|start
+ clk|done|rst_n|sdi|sdo|sh_en|start clk|done|rst_n|sdi|sdo|sh_en|start \$I2758
+ VSS MX2100
* cell instance $572 r0 *1 614.4,936.8
X$572 \$1238 clk|done|rst_n|sdi|sdo|sh_en|start
+ clk|done|rst_n|sdi|sdo|sh_en|start clk|done|rst_n|sdi|sdo|sh_en|start \$I6730
+ VSS MX2100
* cell instance $573 r0 *1 1413.9,480.5
X$573 clk|done|rst_n|sdi|sdo|sh_en|start clk|done|rst_n|sdi|sdo|sh_en|start
+ clk|done|rst_n|sdi|sdo|sh_en|start clk|done|rst_n|sdi|sdo|sh_en|start \$I2747
+ VSS MX2100
* cell instance $574 r0 *1 552,632.6
X$574 clk|done|rst_n|sdi|sdo|sh_en|start clk|done|rst_n|sdi|sdo|sh_en|start
+ clk|done|rst_n|sdi|sdo|sh_en|start clk|done|rst_n|sdi|sdo|sh_en|start \$I6781
+ VSS MX2100
* cell instance $575 r0 *1 1160.4,379.1
X$575 clk|done|rst_n|sdi|sdo|sh_en|start clk|done|rst_n|sdi|sdo|sh_en|start
+ clk|done|rst_n|sdi|sdo|sh_en|start clk|done|rst_n|sdi|sdo|sh_en|start \$I2572
+ VSS MX2100
* cell instance $576 r0 *1 1129.2,784.7
X$576 clk|done|rst_n|sdi|sdo|sh_en|start clk|done|rst_n|sdi|sdo|sh_en|start
+ clk|done|rst_n|sdi|sdo|sh_en|start clk|done|rst_n|sdi|sdo|sh_en|start \$I2758
+ VSS MX2100
* cell instance $577 r0 *1 493.5,1139.6
X$577 clk|done|rst_n|sdi|sdo|sh_en|start clk|done|rst_n|sdi|sdo|sh_en|start
+ clk|done|rst_n|sdi|sdo|sh_en|start clk|done|rst_n|sdi|sdo|sh_en|start \$I6814
+ VSS MX2100
* cell instance $578 r0 *1 1172.1,1595.9
X$578 clk|done|rst_n|sdi|sdo|sh_en|start clk|done|rst_n|sdi|sdo|sh_en|start
+ clk|done|rst_n|sdi|sdo|sh_en|start clk|done|rst_n|sdi|sdo|sh_en|start \$I6827
+ VSS MX2100
* cell instance $579 r0 *1 622.2,632.6
X$579 clk|done|rst_n|sdi|sdo|sh_en|start clk|done|rst_n|sdi|sdo|sh_en|start
+ clk|done|rst_n|sdi|sdo|sh_en|start clk|done|rst_n|sdi|sdo|sh_en|start \$I6781
+ VSS MX2100
* cell instance $580 r0 *1 708,1038.2
X$580 clk|done|rst_n|sdi|sdo|sh_en|start clk|done|rst_n|sdi|sdo|sh_en|start
+ clk|done|rst_n|sdi|sdo|sh_en|start clk|done|rst_n|sdi|sdo|sh_en|start \$I6775
+ VSS MX2100
* cell instance $581 r0 *1 345.3,480.5
X$581 clk|done|rst_n|sdi|sdo|sh_en|start clk|done|rst_n|sdi|sdo|sh_en|start
+ clk|done|rst_n|sdi|sdo|sh_en|start clk|done|rst_n|sdi|sdo|sh_en|start \$I2747
+ VSS MX2100
* cell instance $582 r0 *1 1554.3,1139.6
X$582 clk|done|rst_n|sdi|sdo|sh_en|start clk|done|rst_n|sdi|sdo|sh_en|start
+ clk|done|rst_n|sdi|sdo|sh_en|start clk|done|rst_n|sdi|sdo|sh_en|start \$I6814
+ VSS MX2100
* cell instance $583 r0 *1 1016.1,480.5
X$583 clk|done|rst_n|sdi|sdo|sh_en|start clk|done|rst_n|sdi|sdo|sh_en|start
+ clk|done|rst_n|sdi|sdo|sh_en|start clk|done|rst_n|sdi|sdo|sh_en|start \$I2747
+ VSS MX2100
* cell instance $584 r0 *1 1523.1,1241
X$584 clk|done|rst_n|sdi|sdo|sh_en|start \$1862
+ clk|done|rst_n|sdi|sdo|sh_en|start clk|done|rst_n|sdi|sdo|sh_en|start \$I6818
+ VSS MX2100
* cell instance $585 r0 *1 388.2,1291.7
X$585 \$2019 clk|done|rst_n|sdi|sdo|sh_en|start
+ clk|done|rst_n|sdi|sdo|sh_en|start clk|done|rst_n|sdi|sdo|sh_en|start \$I6812
+ VSS MX2100
* cell instance $586 r0 *1 435,1291.7
X$586 \$2022 clk|done|rst_n|sdi|sdo|sh_en|start
+ clk|done|rst_n|sdi|sdo|sh_en|start clk|done|rst_n|sdi|sdo|sh_en|start \$I6812
+ VSS MX2100
* cell instance $587 r0 *1 1398.3,581.9
X$587 \$366 clk|done|rst_n|sdi|sdo|sh_en|start
+ clk|done|rst_n|sdi|sdo|sh_en|start clk|done|rst_n|sdi|sdo|sh_en|start \$I2828
+ VSS MX2100
* cell instance $588 r0 *1 1117.5,1139.6
X$588 clk|done|rst_n|sdi|sdo|sh_en|start \$1770
+ clk|done|rst_n|sdi|sdo|sh_en|start clk|done|rst_n|sdi|sdo|sh_en|start \$I6814
+ VSS MX2100
* cell instance $589 r0 *1 1250.1,1139.6
X$589 clk|done|rst_n|sdi|sdo|sh_en|start clk|done|rst_n|sdi|sdo|sh_en|start
+ clk|done|rst_n|sdi|sdo|sh_en|start \$1715 \$I6814 VSS MX2100
* cell instance $590 r0 *1 1207.2,835.4
X$590 clk|done|rst_n|sdi|sdo|sh_en|start clk|done|rst_n|sdi|sdo|sh_en|start
+ clk|done|rst_n|sdi|sdo|sh_en|start clk|done|rst_n|sdi|sdo|sh_en|start \$I6760
+ VSS MX2100
* cell instance $591 r0 *1 1172.1,886.1
X$591 clk|done|rst_n|sdi|sdo|sh_en|start clk|done|rst_n|sdi|sdo|sh_en|start
+ clk|done|rst_n|sdi|sdo|sh_en|start clk|done|rst_n|sdi|sdo|sh_en|start \$I6796
+ VSS MX2100
* cell instance $592 r0 *1 470.1,734
X$592 clk|done|rst_n|sdi|sdo|sh_en|start clk|done|rst_n|sdi|sdo|sh_en|start
+ clk|done|rst_n|sdi|sdo|sh_en|start clk|done|rst_n|sdi|sdo|sh_en|start \$I2783
+ VSS MX2100
* cell instance $593 r0 *1 883.5,429.8
X$593 \$236 clk|done|rst_n|sdi|sdo|sh_en|start
+ clk|done|rst_n|sdi|sdo|sh_en|start clk|done|rst_n|sdi|sdo|sh_en|start \$I2762
+ VSS MX2100
* cell instance $594 r0 *1 1515.3,480.5
X$594 clk|done|rst_n|sdi|sdo|sh_en|start clk|done|rst_n|sdi|sdo|sh_en|start
+ clk|done|rst_n|sdi|sdo|sh_en|start clk|done|rst_n|sdi|sdo|sh_en|start \$I2747
+ VSS MX2100
* cell instance $595 r0 *1 1273.5,784.7
X$595 clk|done|rst_n|sdi|sdo|sh_en|start clk|done|rst_n|sdi|sdo|sh_en|start
+ clk|done|rst_n|sdi|sdo|sh_en|start clk|done|rst_n|sdi|sdo|sh_en|start \$I2758
+ VSS MX2100
* cell instance $596 r0 *1 1449,379.1
X$596 clk|done|rst_n|sdi|sdo|sh_en|start clk|done|rst_n|sdi|sdo|sh_en|start
+ clk|done|rst_n|sdi|sdo|sh_en|start clk|done|rst_n|sdi|sdo|sh_en|start \$I2572
+ VSS MX2100
* cell instance $597 r0 *1 848.4,379.1
X$597 clk|done|rst_n|sdi|sdo|sh_en|start clk|done|rst_n|sdi|sdo|sh_en|start
+ clk|done|rst_n|sdi|sdo|sh_en|start clk|done|rst_n|sdi|sdo|sh_en|start \$I2572
+ VSS MX2100
* cell instance $598 r0 *1 1031.7,1443.8
X$598 clk|done|rst_n|sdi|sdo|sh_en|start clk|done|rst_n|sdi|sdo|sh_en|start
+ clk|done|rst_n|sdi|sdo|sh_en|start clk|done|rst_n|sdi|sdo|sh_en|start \$I6819
+ VSS MX2100
* cell instance $599 r0 *1 1530.9,987.5
X$599 \$1374 clk|done|rst_n|sdi|sdo|sh_en|start
+ clk|done|rst_n|sdi|sdo|sh_en|start clk|done|rst_n|sdi|sdo|sh_en|start \$I6725
+ VSS MX2100
* cell instance $600 r0 *1 930.3,581.9
X$600 \$563 clk|done|rst_n|sdi|sdo|sh_en|start
+ clk|done|rst_n|sdi|sdo|sh_en|start clk|done|rst_n|sdi|sdo|sh_en|start \$I2828
+ VSS MX2100
* cell instance $601 r0 *1 501.3,784.7
X$601 clk|done|rst_n|sdi|sdo|sh_en|start clk|done|rst_n|sdi|sdo|sh_en|start
+ clk|done|rst_n|sdi|sdo|sh_en|start clk|done|rst_n|sdi|sdo|sh_en|start \$I2758
+ VSS MX2100
* cell instance $602 r0 *1 606.6,683.3
X$602 \$653 clk|done|rst_n|sdi|sdo|sh_en|start
+ clk|done|rst_n|sdi|sdo|sh_en|start clk|done|rst_n|sdi|sdo|sh_en|start \$I6788
+ VSS MX2100
* cell instance $603 r0 *1 520.8,835.4
X$603 clk|done|rst_n|sdi|sdo|sh_en|start \$1061
+ clk|done|rst_n|sdi|sdo|sh_en|start clk|done|rst_n|sdi|sdo|sh_en|start \$I6760
+ VSS MX2100
* cell instance $604 r0 *1 1160.4,784.7
X$604 clk|done|rst_n|sdi|sdo|sh_en|start clk|done|rst_n|sdi|sdo|sh_en|start
+ clk|done|rst_n|sdi|sdo|sh_en|start clk|done|rst_n|sdi|sdo|sh_en|start \$I2758
+ VSS MX2100
* cell instance $605 r0 *1 376.5,480.5
X$605 \$300 clk|done|rst_n|sdi|sdo|sh_en|start
+ clk|done|rst_n|sdi|sdo|sh_en|start clk|done|rst_n|sdi|sdo|sh_en|start \$I2747
+ VSS MX2100
* cell instance $606 r0 *1 832.8,480.5
X$606 clk|done|rst_n|sdi|sdo|sh_en|start clk|done|rst_n|sdi|sdo|sh_en|start
+ clk|done|rst_n|sdi|sdo|sh_en|start clk|done|rst_n|sdi|sdo|sh_en|start \$I2747
+ VSS MX2100
* cell instance $607 r0 *1 481.8,886.1
X$607 clk|done|rst_n|sdi|sdo|sh_en|start \$1097
+ clk|done|rst_n|sdi|sdo|sh_en|start clk|done|rst_n|sdi|sdo|sh_en|start \$I6796
+ VSS MX2100
* cell instance $608 r0 *1 544.2,784.7
X$608 clk|done|rst_n|sdi|sdo|sh_en|start clk|done|rst_n|sdi|sdo|sh_en|start
+ clk|done|rst_n|sdi|sdo|sh_en|start clk|done|rst_n|sdi|sdo|sh_en|start \$I2758
+ VSS MX2100
* cell instance $609 r0 *1 1304.7,886.1
X$609 clk|done|rst_n|sdi|sdo|sh_en|start clk|done|rst_n|sdi|sdo|sh_en|start
+ clk|done|rst_n|sdi|sdo|sh_en|start clk|done|rst_n|sdi|sdo|sh_en|start \$I6796
+ VSS MX2100
* cell instance $610 r0 *1 403.8,1241
X$610 \$1893 clk|done|rst_n|sdi|sdo|sh_en|start
+ clk|done|rst_n|sdi|sdo|sh_en|start clk|done|rst_n|sdi|sdo|sh_en|start \$I6818
+ VSS MX2100
* cell instance $611 r0 *1 864,480.5
X$611 clk|done|rst_n|sdi|sdo|sh_en|start clk|done|rst_n|sdi|sdo|sh_en|start
+ clk|done|rst_n|sdi|sdo|sh_en|start clk|done|rst_n|sdi|sdo|sh_en|start \$I2747
+ VSS MX2100
* cell instance $612 r0 *1 1090.2,835.4
X$612 clk|done|rst_n|sdi|sdo|sh_en|start clk|done|rst_n|sdi|sdo|sh_en|start
+ clk|done|rst_n|sdi|sdo|sh_en|start clk|done|rst_n|sdi|sdo|sh_en|start \$I6760
+ VSS MX2100
* cell instance $613 r0 *1 415.5,1190.3
X$613 \$1693 clk|done|rst_n|sdi|sdo|sh_en|start
+ clk|done|rst_n|sdi|sdo|sh_en|start clk|done|rst_n|sdi|sdo|sh_en|start \$I6808
+ VSS MX2100
* cell instance $614 r0 *1 575.4,531.2
X$614 clk|done|rst_n|sdi|sdo|sh_en|start clk|done|rst_n|sdi|sdo|sh_en|start
+ clk|done|rst_n|sdi|sdo|sh_en|start clk|done|rst_n|sdi|sdo|sh_en|start \$I2745
+ VSS MX2100
* cell instance $615 r0 *1 1004.4,835.4
X$615 clk|done|rst_n|sdi|sdo|sh_en|start clk|done|rst_n|sdi|sdo|sh_en|start
+ clk|done|rst_n|sdi|sdo|sh_en|start clk|done|rst_n|sdi|sdo|sh_en|start \$I6760
+ VSS MX2100
* cell instance $616 r0 *1 583.2,886.1
X$616 clk|done|rst_n|sdi|sdo|sh_en|start clk|done|rst_n|sdi|sdo|sh_en|start
+ clk|done|rst_n|sdi|sdo|sh_en|start clk|done|rst_n|sdi|sdo|sh_en|start \$I6796
+ VSS MX2100
* cell instance $617 r0 *1 376.5,835.4
X$617 \$1050 clk|done|rst_n|sdi|sdo|sh_en|start
+ clk|done|rst_n|sdi|sdo|sh_en|start clk|done|rst_n|sdi|sdo|sh_en|start \$I6760
+ VSS MX2100
* cell instance $618 r0 *1 883.5,328.4
X$618 clk|done|rst_n|sdi|sdo|sh_en|start clk|done|rst_n|sdi|sdo|sh_en|start
+ clk|done|rst_n|sdi|sdo|sh_en|start clk|done|rst_n|sdi|sdo|sh_en|start \$I2245
+ VSS MX2100
* cell instance $619 r0 *1 1523.1,1139.6
X$619 clk|done|rst_n|sdi|sdo|sh_en|start clk|done|rst_n|sdi|sdo|sh_en|start
+ clk|done|rst_n|sdi|sdo|sh_en|start clk|done|rst_n|sdi|sdo|sh_en|start \$I6814
+ VSS MX2100
* cell instance $620 r0 *1 704.1,429.8
X$620 clk|done|rst_n|sdi|sdo|sh_en|start \$28
+ clk|done|rst_n|sdi|sdo|sh_en|start clk|done|rst_n|sdi|sdo|sh_en|start \$I2762
+ VSS MX2100
* cell instance $621 r0 *1 1519.2,581.9
X$621 \$516 clk|done|rst_n|sdi|sdo|sh_en|start
+ clk|done|rst_n|sdi|sdo|sh_en|start clk|done|rst_n|sdi|sdo|sh_en|start \$I2828
+ VSS MX2100
* cell instance $622 r0 *1 548.1,886.1
X$622 clk|done|rst_n|sdi|sdo|sh_en|start clk|done|rst_n|sdi|sdo|sh_en|start
+ clk|done|rst_n|sdi|sdo|sh_en|start clk|done|rst_n|sdi|sdo|sh_en|start \$I6796
+ VSS MX2100
* cell instance $623 r0 *1 384.3,1393.1
X$623 clk|done|rst_n|sdi|sdo|sh_en|start clk|done|rst_n|sdi|sdo|sh_en|start
+ clk|done|rst_n|sdi|sdo|sh_en|start clk|done|rst_n|sdi|sdo|sh_en|start \$I6830
+ VSS MX2100
* cell instance $624 r0 *1 614.4,531.2
X$624 clk|done|rst_n|sdi|sdo|sh_en|start clk|done|rst_n|sdi|sdo|sh_en|start
+ clk|done|rst_n|sdi|sdo|sh_en|start clk|done|rst_n|sdi|sdo|sh_en|start \$I2745
+ VSS MX2100
* cell instance $625 r0 *1 1281.3,531.2
X$625 clk|done|rst_n|sdi|sdo|sh_en|start clk|done|rst_n|sdi|sdo|sh_en|start
+ clk|done|rst_n|sdi|sdo|sh_en|start clk|done|rst_n|sdi|sdo|sh_en|start \$I2745
+ VSS MX2100
* cell instance $626 r0 *1 364.8,987.5
X$626 clk|done|rst_n|sdi|sdo|sh_en|start \$1259
+ clk|done|rst_n|sdi|sdo|sh_en|start clk|done|rst_n|sdi|sdo|sh_en|start \$I6725
+ VSS MX2100
* cell instance $627 r0 *1 657.3,784.7
X$627 clk|done|rst_n|sdi|sdo|sh_en|start clk|done|rst_n|sdi|sdo|sh_en|start
+ clk|done|rst_n|sdi|sdo|sh_en|start clk|done|rst_n|sdi|sdo|sh_en|start \$I2758
+ VSS MX2100
* cell instance $628 r0 *1 594.9,784.7
X$628 clk|done|rst_n|sdi|sdo|sh_en|start clk|done|rst_n|sdi|sdo|sh_en|start
+ clk|done|rst_n|sdi|sdo|sh_en|start clk|done|rst_n|sdi|sdo|sh_en|start \$I2758
+ VSS MX2100
* cell instance $629 r0 *1 1222.8,531.2
X$629 clk|done|rst_n|sdi|sdo|sh_en|start clk|done|rst_n|sdi|sdo|sh_en|start
+ clk|done|rst_n|sdi|sdo|sh_en|start clk|done|rst_n|sdi|sdo|sh_en|start \$I2745
+ VSS MX2100
* cell instance $630 r0 *1 1312.5,531.2
X$630 clk|done|rst_n|sdi|sdo|sh_en|start clk|done|rst_n|sdi|sdo|sh_en|start
+ clk|done|rst_n|sdi|sdo|sh_en|start clk|done|rst_n|sdi|sdo|sh_en|start \$I2745
+ VSS MX2100
* cell instance $631 r0 *1 481.8,581.9
X$631 clk|done|rst_n|sdi|sdo|sh_en|start clk|done|rst_n|sdi|sdo|sh_en|start
+ clk|done|rst_n|sdi|sdo|sh_en|start clk|done|rst_n|sdi|sdo|sh_en|start \$I2828
+ VSS MX2100
* cell instance $632 r0 *1 1554.3,1038.2
X$632 \$1532 \$1441 clk|done|rst_n|sdi|sdo|sh_en|start
+ clk|done|rst_n|sdi|sdo|sh_en|start \$I6775 VSS MX2100
* cell instance $633 r0 *1 544.2,429.8
X$633 \$8 clk|done|rst_n|sdi|sdo|sh_en|start clk|done|rst_n|sdi|sdo|sh_en|start
+ clk|done|rst_n|sdi|sdo|sh_en|start \$I2762 VSS MX2100
* cell instance $634 r0 *1 396,987.5
X$634 clk|done|rst_n|sdi|sdo|sh_en|start clk|done|rst_n|sdi|sdo|sh_en|start
+ clk|done|rst_n|sdi|sdo|sh_en|start clk|done|rst_n|sdi|sdo|sh_en|start \$I6725
+ VSS MX2100
* cell instance $635 r0 *1 442.8,581.9
X$635 clk|done|rst_n|sdi|sdo|sh_en|start clk|done|rst_n|sdi|sdo|sh_en|start
+ clk|done|rst_n|sdi|sdo|sh_en|start clk|done|rst_n|sdi|sdo|sh_en|start \$I2828
+ VSS MX2100
* cell instance $636 r0 *1 984.9,784.7
X$636 clk|done|rst_n|sdi|sdo|sh_en|start clk|done|rst_n|sdi|sdo|sh_en|start
+ clk|done|rst_n|sdi|sdo|sh_en|start clk|done|rst_n|sdi|sdo|sh_en|start \$I2758
+ VSS MX2100
* cell instance $637 r0 *1 384.3,581.9
X$637 clk|done|rst_n|sdi|sdo|sh_en|start clk|done|rst_n|sdi|sdo|sh_en|start
+ clk|done|rst_n|sdi|sdo|sh_en|start clk|done|rst_n|sdi|sdo|sh_en|start \$I2828
+ VSS MX2100
* cell instance $638 r0 *1 341.4,531.2
X$638 clk|done|rst_n|sdi|sdo|sh_en|start clk|done|rst_n|sdi|sdo|sh_en|start
+ clk|done|rst_n|sdi|sdo|sh_en|start clk|done|rst_n|sdi|sdo|sh_en|start \$I2745
+ VSS MX2100
* cell instance $639 r0 *1 786,886.1
X$639 clk|done|rst_n|sdi|sdo|sh_en|start clk|done|rst_n|sdi|sdo|sh_en|start
+ clk|done|rst_n|sdi|sdo|sh_en|start clk|done|rst_n|sdi|sdo|sh_en|start \$I6796
+ VSS MX2100
* cell instance $640 r0 *1 415.5,1038.2
X$640 \$1477 clk|done|rst_n|sdi|sdo|sh_en|start
+ clk|done|rst_n|sdi|sdo|sh_en|start clk|done|rst_n|sdi|sdo|sh_en|start \$I6775
+ VSS MX2100
* cell instance $641 r0 *1 969.3,480.5
X$641 clk|done|rst_n|sdi|sdo|sh_en|start clk|done|rst_n|sdi|sdo|sh_en|start
+ clk|done|rst_n|sdi|sdo|sh_en|start clk|done|rst_n|sdi|sdo|sh_en|start \$I2747
+ VSS MX2100
* cell instance $642 r0 *1 977.1,632.6
X$642 clk|done|rst_n|sdi|sdo|sh_en|start clk|done|rst_n|sdi|sdo|sh_en|start
+ clk|done|rst_n|sdi|sdo|sh_en|start clk|done|rst_n|sdi|sdo|sh_en|start \$I6781
+ VSS MX2100
* cell instance $643 r0 *1 1421.7,936.8
X$643 clk|done|rst_n|sdi|sdo|sh_en|start clk|done|rst_n|sdi|sdo|sh_en|start
+ clk|done|rst_n|sdi|sdo|sh_en|start clk|done|rst_n|sdi|sdo|sh_en|start \$I6730
+ VSS MX2100
* cell instance $644 r0 *1 711.9,886.1
X$644 clk|done|rst_n|sdi|sdo|sh_en|start clk|done|rst_n|sdi|sdo|sh_en|start
+ clk|done|rst_n|sdi|sdo|sh_en|start clk|done|rst_n|sdi|sdo|sh_en|start \$I6796
+ VSS MX2100
* cell instance $645 r0 *1 415.5,734
X$645 \$752 clk|done|rst_n|sdi|sdo|sh_en|start
+ clk|done|rst_n|sdi|sdo|sh_en|start clk|done|rst_n|sdi|sdo|sh_en|start \$I2783
+ VSS MX2100
* cell instance $646 r0 *1 1558.2,886.1
X$646 clk|done|rst_n|sdi|sdo|sh_en|start clk|done|rst_n|sdi|sdo|sh_en|start
+ clk|done|rst_n|sdi|sdo|sh_en|start clk|done|rst_n|sdi|sdo|sh_en|start \$I6796
+ VSS MX2100
* cell instance $647 r0 *1 1390.5,835.4
X$647 clk|done|rst_n|sdi|sdo|sh_en|start clk|done|rst_n|sdi|sdo|sh_en|start
+ clk|done|rst_n|sdi|sdo|sh_en|start clk|done|rst_n|sdi|sdo|sh_en|start \$I6760
+ VSS MX2100
* cell instance $648 r0 *1 392.1,1443.8
X$648 \$2345 \$2343 clk|done|rst_n|sdi|sdo|sh_en|start
+ clk|done|rst_n|sdi|sdo|sh_en|start \$I6819 VSS MX2100
* cell instance $649 r0 *1 353.1,1393.1
X$649 clk|done|rst_n|sdi|sdo|sh_en|start clk|done|rst_n|sdi|sdo|sh_en|start
+ clk|done|rst_n|sdi|sdo|sh_en|start clk|done|rst_n|sdi|sdo|sh_en|start \$I6830
+ VSS MX2100
* cell instance $650 r0 *1 688.5,784.7
X$650 clk|done|rst_n|sdi|sdo|sh_en|start clk|done|rst_n|sdi|sdo|sh_en|start
+ clk|done|rst_n|sdi|sdo|sh_en|start clk|done|rst_n|sdi|sdo|sh_en|start \$I2758
+ VSS MX2100
* cell instance $651 r0 *1 770.4,734
X$651 clk|done|rst_n|sdi|sdo|sh_en|start clk|done|rst_n|sdi|sdo|sh_en|start
+ clk|done|rst_n|sdi|sdo|sh_en|start clk|done|rst_n|sdi|sdo|sh_en|start \$I2783
+ VSS MX2100
* cell instance $652 r0 *1 1094.1,581.9
X$652 clk|done|rst_n|sdi|sdo|sh_en|start clk|done|rst_n|sdi|sdo|sh_en|start
+ clk|done|rst_n|sdi|sdo|sh_en|start clk|done|rst_n|sdi|sdo|sh_en|start \$I2828
+ VSS MX2100
* cell instance $653 r0 *1 1082.4,531.2
X$653 clk|done|rst_n|sdi|sdo|sh_en|start clk|done|rst_n|sdi|sdo|sh_en|start
+ clk|done|rst_n|sdi|sdo|sh_en|start clk|done|rst_n|sdi|sdo|sh_en|start \$I2745
+ VSS MX2100
* cell instance $654 r0 *1 583.2,1443.8
X$654 clk|done|rst_n|sdi|sdo|sh_en|start clk|done|rst_n|sdi|sdo|sh_en|start
+ clk|done|rst_n|sdi|sdo|sh_en|start clk|done|rst_n|sdi|sdo|sh_en|start \$I6819
+ VSS MX2100
* cell instance $655 r0 *1 786,784.7
X$655 clk|done|rst_n|sdi|sdo|sh_en|start clk|done|rst_n|sdi|sdo|sh_en|start
+ clk|done|rst_n|sdi|sdo|sh_en|start clk|done|rst_n|sdi|sdo|sh_en|start \$I2758
+ VSS MX2100
* cell instance $656 r0 *1 1566,835.4
X$656 clk|done|rst_n|sdi|sdo|sh_en|start clk|done|rst_n|sdi|sdo|sh_en|start
+ clk|done|rst_n|sdi|sdo|sh_en|start clk|done|rst_n|sdi|sdo|sh_en|start \$I6760
+ VSS MX2100
* cell instance $657 r0 *1 735.3,987.5
X$657 \$1288 clk|done|rst_n|sdi|sdo|sh_en|start
+ clk|done|rst_n|sdi|sdo|sh_en|start clk|done|rst_n|sdi|sdo|sh_en|start \$I6725
+ VSS MX2100
* cell instance $658 r0 *1 587.1,1088.9
X$658 clk|done|rst_n|sdi|sdo|sh_en|start clk|done|rst_n|sdi|sdo|sh_en|start
+ clk|done|rst_n|sdi|sdo|sh_en|start clk|done|rst_n|sdi|sdo|sh_en|start \$I6789
+ VSS MX2100
* cell instance $659 r0 *1 708,734
X$659 \$760 clk|done|rst_n|sdi|sdo|sh_en|start
+ clk|done|rst_n|sdi|sdo|sh_en|start clk|done|rst_n|sdi|sdo|sh_en|start \$I2783
+ VSS MX2100
* cell instance $660 r0 *1 774.3,1038.2
X$660 clk|done|rst_n|sdi|sdo|sh_en|start clk|done|rst_n|sdi|sdo|sh_en|start
+ clk|done|rst_n|sdi|sdo|sh_en|start clk|done|rst_n|sdi|sdo|sh_en|start \$I6775
+ VSS MX2100
* cell instance $661 r0 *1 602.7,1038.2
X$661 \$1491 \$1456 clk|done|rst_n|sdi|sdo|sh_en|start
+ clk|done|rst_n|sdi|sdo|sh_en|start \$I6775 VSS MX2100
* cell instance $662 r0 *1 555.9,1088.9
X$662 clk|done|rst_n|sdi|sdo|sh_en|start \$1395
+ clk|done|rst_n|sdi|sdo|sh_en|start clk|done|rst_n|sdi|sdo|sh_en|start \$I6789
+ VSS MX2100
* cell instance $663 r0 *1 380.4,429.8
X$663 clk|done|rst_n|sdi|sdo|sh_en|start \$72
+ clk|done|rst_n|sdi|sdo|sh_en|start clk|done|rst_n|sdi|sdo|sh_en|start \$I2762
+ VSS MX2100
* cell instance $664 r0 *1 555.9,1595.9
X$664 \$2677 clk|done|rst_n|sdi|sdo|sh_en|start
+ clk|done|rst_n|sdi|sdo|sh_en|start clk|done|rst_n|sdi|sdo|sh_en|start \$I6827
+ VSS MX2100
* cell instance $665 r0 *1 1402.2,379.1
X$665 \$128 clk|done|rst_n|sdi|sdo|sh_en|start
+ clk|done|rst_n|sdi|sdo|sh_en|start clk|done|rst_n|sdi|sdo|sh_en|start \$I2572
+ VSS MX2100
* cell instance $666 r0 *1 633.9,1545.2
X$666 clk|done|rst_n|sdi|sdo|sh_en|start clk|done|rst_n|sdi|sdo|sh_en|start
+ clk|done|rst_n|sdi|sdo|sh_en|start clk|done|rst_n|sdi|sdo|sh_en|start \$I6832
+ VSS MX2100
* cell instance $667 r0 *1 988.8,936.8
X$667 \$1244 clk|done|rst_n|sdi|sdo|sh_en|start
+ clk|done|rst_n|sdi|sdo|sh_en|start clk|done|rst_n|sdi|sdo|sh_en|start \$I6730
+ VSS MX2100
* cell instance $668 r0 *1 1016.1,379.1
X$668 \$87 clk|done|rst_n|sdi|sdo|sh_en|start
+ clk|done|rst_n|sdi|sdo|sh_en|start clk|done|rst_n|sdi|sdo|sh_en|start \$I2572
+ VSS MX2100
* cell instance $669 r0 *1 1020,1038.2
X$669 \$1472 clk|done|rst_n|sdi|sdo|sh_en|start
+ clk|done|rst_n|sdi|sdo|sh_en|start clk|done|rst_n|sdi|sdo|sh_en|start \$I6775
+ VSS MX2100
* cell instance $670 r0 *1 1328.1,379.1
X$670 \$125 clk|done|rst_n|sdi|sdo|sh_en|start
+ clk|done|rst_n|sdi|sdo|sh_en|start clk|done|rst_n|sdi|sdo|sh_en|start \$I2572
+ VSS MX2100
* cell instance $671 r0 *1 1101.9,1038.2
X$671 clk|done|rst_n|sdi|sdo|sh_en|start clk|done|rst_n|sdi|sdo|sh_en|start
+ clk|done|rst_n|sdi|sdo|sh_en|start clk|done|rst_n|sdi|sdo|sh_en|start \$I6775
+ VSS MX2100
* cell instance $672 r0 *1 1051.2,987.5
X$672 clk|done|rst_n|sdi|sdo|sh_en|start clk|done|rst_n|sdi|sdo|sh_en|start
+ clk|done|rst_n|sdi|sdo|sh_en|start clk|done|rst_n|sdi|sdo|sh_en|start \$I6725
+ VSS MX2100
* cell instance $673 r0 *1 1059,379.1
X$673 \$115 clk|done|rst_n|sdi|sdo|sh_en|start
+ clk|done|rst_n|sdi|sdo|sh_en|start clk|done|rst_n|sdi|sdo|sh_en|start \$I2572
+ VSS MX2100
* cell instance $674 r0 *1 1406.1,632.6
X$674 clk|done|rst_n|sdi|sdo|sh_en|start clk|done|rst_n|sdi|sdo|sh_en|start
+ clk|done|rst_n|sdi|sdo|sh_en|start clk|done|rst_n|sdi|sdo|sh_en|start \$I6781
+ VSS MX2100
* cell instance $675 r0 *1 1129.2,379.1
X$675 clk|done|rst_n|sdi|sdo|sh_en|start clk|done|rst_n|sdi|sdo|sh_en|start
+ clk|done|rst_n|sdi|sdo|sh_en|start clk|done|rst_n|sdi|sdo|sh_en|start \$I2572
+ VSS MX2100
* cell instance $676 r0 *1 481.8,429.8
X$676 \$203 clk|done|rst_n|sdi|sdo|sh_en|start
+ clk|done|rst_n|sdi|sdo|sh_en|start clk|done|rst_n|sdi|sdo|sh_en|start \$I2762
+ VSS MX2100
* cell instance $677 r0 *1 1566,632.6
X$677 \$707 clk|done|rst_n|sdi|sdo|sh_en|start
+ clk|done|rst_n|sdi|sdo|sh_en|start clk|done|rst_n|sdi|sdo|sh_en|start \$I6781
+ VSS MX2100
* cell instance $678 r0 *1 1078.5,632.6
X$678 clk|done|rst_n|sdi|sdo|sh_en|start clk|done|rst_n|sdi|sdo|sh_en|start
+ clk|done|rst_n|sdi|sdo|sh_en|start clk|done|rst_n|sdi|sdo|sh_en|start \$I6781
+ VSS MX2100
* cell instance $679 r0 *1 1569.9,683.3
X$679 clk|done|rst_n|sdi|sdo|sh_en|start clk|done|rst_n|sdi|sdo|sh_en|start
+ clk|done|rst_n|sdi|sdo|sh_en|start clk|done|rst_n|sdi|sdo|sh_en|start \$I6788
+ VSS MX2100
* cell instance $680 r0 *1 384.3,1545.2
X$680 clk|done|rst_n|sdi|sdo|sh_en|start clk|done|rst_n|sdi|sdo|sh_en|start
+ clk|done|rst_n|sdi|sdo|sh_en|start clk|done|rst_n|sdi|sdo|sh_en|start \$I6832
+ VSS MX2100
* cell instance $681 r0 *1 435,1545.2
X$681 \$2588 clk|done|rst_n|sdi|sdo|sh_en|start
+ clk|done|rst_n|sdi|sdo|sh_en|start clk|done|rst_n|sdi|sdo|sh_en|start \$I6832
+ VSS MX2100
* cell instance $682 r0 *1 840.6,429.8
X$682 clk|done|rst_n|sdi|sdo|sh_en|start clk|done|rst_n|sdi|sdo|sh_en|start
+ clk|done|rst_n|sdi|sdo|sh_en|start clk|done|rst_n|sdi|sdo|sh_en|start \$I2762
+ VSS MX2100
* cell instance $683 r0 *1 555.9,1393.1
X$683 \$2231 clk|done|rst_n|sdi|sdo|sh_en|start
+ clk|done|rst_n|sdi|sdo|sh_en|start clk|done|rst_n|sdi|sdo|sh_en|start \$I6830
+ VSS MX2100
* cell instance $684 r0 *1 384.3,734
X$684 \$748 clk|done|rst_n|sdi|sdo|sh_en|start
+ clk|done|rst_n|sdi|sdo|sh_en|start clk|done|rst_n|sdi|sdo|sh_en|start \$I2783
+ VSS MX2100
* cell instance $685 r0 *1 1296.9,379.1
X$685 clk|done|rst_n|sdi|sdo|sh_en|start clk|done|rst_n|sdi|sdo|sh_en|start
+ clk|done|rst_n|sdi|sdo|sh_en|start clk|done|rst_n|sdi|sdo|sh_en|start \$I2572
+ VSS MX2100
* cell instance $686 r0 *1 505.2,531.2
X$686 \$435 \$434 clk|done|rst_n|sdi|sdo|sh_en|start
+ clk|done|rst_n|sdi|sdo|sh_en|start \$I2745 VSS MX2100
* cell instance $687 r0 *1 1558.2,784.7
X$687 clk|done|rst_n|sdi|sdo|sh_en|start clk|done|rst_n|sdi|sdo|sh_en|start
+ clk|done|rst_n|sdi|sdo|sh_en|start clk|done|rst_n|sdi|sdo|sh_en|start \$I2758
+ VSS MX2100
* cell instance $688 r0 *1 587.1,429.8
X$688 clk|done|rst_n|sdi|sdo|sh_en|start \$79
+ clk|done|rst_n|sdi|sdo|sh_en|start clk|done|rst_n|sdi|sdo|sh_en|start \$I2762
+ VSS MX2100
* cell instance $689 r0 *1 513,429.8
X$689 clk|done|rst_n|sdi|sdo|sh_en|start \$271 \$203
+ clk|done|rst_n|sdi|sdo|sh_en|start \$I2762 VSS MX2100
* cell instance $690 r0 *1 1137,1190.3
X$690 clk|done|rst_n|sdi|sdo|sh_en|start clk|done|rst_n|sdi|sdo|sh_en|start
+ \$1855 clk|done|rst_n|sdi|sdo|sh_en|start \$I6808 VSS MX2100
* cell instance $691 r0 *1 1554.3,1241
X$691 clk|done|rst_n|sdi|sdo|sh_en|start clk|done|rst_n|sdi|sdo|sh_en|start
+ \$1862 clk|done|rst_n|sdi|sdo|sh_en|start \$I6818 VSS MX2100
* cell instance $692 r0 *1 384.3,1190.3
X$692 \$1788 clk|done|rst_n|sdi|sdo|sh_en|start \$1745
+ clk|done|rst_n|sdi|sdo|sh_en|start \$I6808 VSS MX2100
* cell instance $693 r0 *1 914.7,429.8
X$693 clk|done|rst_n|sdi|sdo|sh_en|start \$202 \$236
+ clk|done|rst_n|sdi|sdo|sh_en|start \$I2762 VSS MX2100
* cell instance $694 r0 *1 493.5,936.8
X$694 clk|done|rst_n|sdi|sdo|sh_en|start clk|done|rst_n|sdi|sdo|sh_en|start
+ \$1259 clk|done|rst_n|sdi|sdo|sh_en|start \$I6730 VSS MX2100
* cell instance $695 r0 *1 848.4,581.9
X$695 clk|done|rst_n|sdi|sdo|sh_en|start clk|done|rst_n|sdi|sdo|sh_en|start
+ \$555 clk|done|rst_n|sdi|sdo|sh_en|start \$I2828 VSS MX2100
* cell instance $696 r0 *1 333.6,886.1
X$696 \$1143 clk|done|rst_n|sdi|sdo|sh_en|start \$1144
+ clk|done|rst_n|sdi|sdo|sh_en|start \$I6796 VSS MX2100
* cell instance $697 r0 *1 1523.1,1038.2
X$697 clk|done|rst_n|sdi|sdo|sh_en|start clk|done|rst_n|sdi|sdo|sh_en|start
+ \$1441 clk|done|rst_n|sdi|sdo|sh_en|start \$I6775 VSS MX2100
* cell instance $698 r0 *1 1437.3,1494.5
X$698 clk|done|rst_n|sdi|sdo|sh_en|start clk|done|rst_n|sdi|sdo|sh_en|start
+ \$2420 clk|done|rst_n|sdi|sdo|sh_en|start \$I6833 VSS MX2100
* cell instance $699 r0 *1 536.4,1038.2
X$699 \$1452 clk|done|rst_n|sdi|sdo|sh_en|start \$1395
+ clk|done|rst_n|sdi|sdo|sh_en|start \$I6775 VSS MX2100
* cell instance $700 r0 *1 750.9,480.5
X$700 \$I2747 clk|done|rst_n|sdi|sdo|sh_en|start
+ clk|done|rst_n|sdi|sdo|sh_en|start VSS BUFF00
* cell instance $701 r0 *1 981,328.4
X$701 \$I2245 clk|done|rst_n|sdi|sdo|sh_en|start
+ clk|done|rst_n|sdi|sdo|sh_en|start VSS BUFF00
* cell instance $702 r0 *1 805.5,1038.2
X$702 \$I6775 clk|done|rst_n|sdi|sdo|sh_en|start
+ clk|done|rst_n|sdi|sdo|sh_en|start VSS BUFF00
* cell instance $703 r0 *1 1059,328.4
X$703 \$I2245 clk|done|rst_n|sdi|sdo|sh_en|start
+ clk|done|rst_n|sdi|sdo|sh_en|start VSS BUFF00
* cell instance $704 r0 *1 754.8,429.8
X$704 \$I2762 clk|done|rst_n|sdi|sdo|sh_en|start
+ clk|done|rst_n|sdi|sdo|sh_en|start VSS BUFF00
* cell instance $705 r0 *1 770.4,1088.9
X$705 \$I6789 clk|done|rst_n|sdi|sdo|sh_en|start
+ clk|done|rst_n|sdi|sdo|sh_en|start VSS BUFF00
* cell instance $706 r0 *1 758.7,1038.2
X$706 \$I6775 clk|done|rst_n|sdi|sdo|sh_en|start
+ clk|done|rst_n|sdi|sdo|sh_en|start VSS BUFF00
* cell instance $707 r0 *1 789.9,328.4
X$707 \$I2245 clk|done|rst_n|sdi|sdo|sh_en|start
+ clk|done|rst_n|sdi|sdo|sh_en|start VSS BUFF00
* cell instance $708 r0 *1 969.3,784.7
X$708 \$I2758 clk|done|rst_n|sdi|sdo|sh_en|start
+ clk|done|rst_n|sdi|sdo|sh_en|start VSS BUFF00
* cell instance $709 r0 *1 532.5,683.3
X$709 \$I6788 \$756 clk|done|rst_n|sdi|sdo|sh_en|start VSS INVR00
* cell instance $710 r0 *1 360.9,683.3
X$710 \$I6788 \$734 clk|done|rst_n|sdi|sdo|sh_en|start VSS INVR00
* cell instance $711 r0 *1 949.8,429.8
X$711 \$I2762 \$202 clk|done|rst_n|sdi|sdo|sh_en|start VSS INVR00
* cell instance $712 r0 *1 774.3,581.9
X$712 \$I2828 clk|done|rst_n|sdi|sdo|sh_en|start
+ clk|done|rst_n|sdi|sdo|sh_en|start VSS INVR00
* cell instance $713 r0 *1 427.2,429.8
X$713 \$I2762 clk|done|rst_n|sdi|sdo|sh_en|start
+ clk|done|rst_n|sdi|sdo|sh_en|start VSS INVR00
* cell instance $714 r0 *1 696.3,1038.2
X$714 \$I6775 \$1459 clk|done|rst_n|sdi|sdo|sh_en|start VSS INVR00
* cell instance $715 r0 *1 821.1,784.7
X$715 \$I2758 \$971 clk|done|rst_n|sdi|sdo|sh_en|start VSS INVR00
* cell instance $716 r0 *1 879.6,1595.9
X$716 \$I6827 clk|done|rst_n|sdi|sdo|sh_en|start
+ clk|done|rst_n|sdi|sdo|sh_en|start VSS INVR00
* cell instance $717 r0 *1 630,480.5
X$717 \$I2747 clk|done|rst_n|sdi|sdo|sh_en|start
+ clk|done|rst_n|sdi|sdo|sh_en|start VSS INVR00
* cell instance $718 r0 *1 743.1,429.8
X$718 \$I2762 clk|done|rst_n|sdi|sdo|sh_en|start
+ clk|done|rst_n|sdi|sdo|sh_en|start VSS INVR00
* cell instance $719 r0 *1 778.2,480.5
X$719 \$I2747 \$345 clk|done|rst_n|sdi|sdo|sh_en|start VSS INVR00
* cell instance $720 r0 *1 470.1,886.1
X$720 \$I6796 \$1129 clk|done|rst_n|sdi|sdo|sh_en|start VSS INVR00
* cell instance $721 r0 *1 692.4,429.8
X$721 \$I2762 \$208 clk|done|rst_n|sdi|sdo|sh_en|start VSS INVR00
* cell instance $722 r0 *1 825,379.1
X$722 \$I2572 clk|done|rst_n|sdi|sdo|sh_en|start
+ clk|done|rst_n|sdi|sdo|sh_en|start VSS INVR00
* cell instance $723 r0 *1 357,429.8
X$723 \$I2762 \$191 clk|done|rst_n|sdi|sdo|sh_en|start VSS INVR00
* cell instance $724 r0 *1 1324.2,784.7
X$724 \$I2758 \$953 clk|done|rst_n|sdi|sdo|sh_en|start VSS INVR00
* cell instance $725 r0 *1 895.2,1190.3
X$725 \$I6808 \$1848 clk|done|rst_n|sdi|sdo|sh_en|start VSS INVR00
* cell instance $726 r0 *1 848.4,531.2
X$726 \$I2745 \$424 clk|done|rst_n|sdi|sdo|sh_en|start VSS INVR00
* cell instance $727 r0 *1 762.6,1393.1
X$727 \$I6830 clk|done|rst_n|sdi|sdo|sh_en|start
+ clk|done|rst_n|sdi|sdo|sh_en|start VSS INVR00
* cell instance $728 r0 *1 844.5,1038.2
X$728 \$I6775 clk|done|rst_n|sdi|sdo|sh_en|start
+ clk|done|rst_n|sdi|sdo|sh_en|start VSS INVR00
* cell instance $729 r0 *1 591,936.8
X$729 \$I6730 clk|done|rst_n|sdi|sdo|sh_en|start
+ clk|done|rst_n|sdi|sdo|sh_en|start VSS INVR00
* cell instance $730 r0 *1 903,1241
X$730 \$I6818 clk|done|rst_n|sdi|sdo|sh_en|start
+ clk|done|rst_n|sdi|sdo|sh_en|start VSS INVR00
* cell instance $731 r0 *1 1605,1443.8
X$731 \$I6819 \$2429 clk|done|rst_n|sdi|sdo|sh_en|start VSS INVR00
* cell instance $732 r0 *1 407.7,379.1
X$732 \$I2572 clk|done|rst_n|sdi|sdo|sh_en|start
+ clk|done|rst_n|sdi|sdo|sh_en|start VSS INVR00
* cell instance $733 r0 *1 353.1,987.5
X$733 \$I6725 \$1345 clk|done|rst_n|sdi|sdo|sh_en|start VSS INVR00
* cell instance $734 r0 *1 696.3,632.6
X$734 \$I6781 clk|done|rst_n|sdi|sdo|sh_en|start
+ clk|done|rst_n|sdi|sdo|sh_en|start VSS INVR00
* cell instance $735 r0 *1 1363.2,480.5
X$735 \$I2747 clk|done|rst_n|sdi|sdo|sh_en|start
+ clk|done|rst_n|sdi|sdo|sh_en|start VSS INVR00
* cell instance $736 r0 *1 797.7,1241
X$736 \$I6818 clk|done|rst_n|sdi|sdo|sh_en|start
+ clk|done|rst_n|sdi|sdo|sh_en|start VSS INVR00
* cell instance $737 r0 *1 649.5,936.8
X$737 \$I6730 clk|done|rst_n|sdi|sdo|sh_en|start
+ clk|done|rst_n|sdi|sdo|sh_en|start VSS INVR00
* cell instance $738 r0 *1 1109.7,1443.8
X$738 \$I6819 clk|done|rst_n|sdi|sdo|sh_en|start
+ clk|done|rst_n|sdi|sdo|sh_en|start VSS INVR00
* cell instance $739 r0 *1 528.6,632.6
X$739 \$I6781 \$651 clk|done|rst_n|sdi|sdo|sh_en|start VSS INVR00
* cell instance $740 r0 *1 454.5,1190.3
X$740 \$I6808 \$1821 clk|done|rst_n|sdi|sdo|sh_en|start VSS INVR00
* cell instance $741 r0 *1 723.6,581.9
X$741 \$I2828 \$525 clk|done|rst_n|sdi|sdo|sh_en|start VSS INVR00
* cell instance $742 r0 *1 1464.6,480.5
X$742 \$I2747 clk|done|rst_n|sdi|sdo|sh_en|start
+ clk|done|rst_n|sdi|sdo|sh_en|start VSS INVR00
* cell instance $743 r0 *1 700.2,581.9
X$743 \$I2828 \$523 clk|done|rst_n|sdi|sdo|sh_en|start VSS INVR00
* cell instance $744 r0 *1 1039.5,835.4
X$744 \$I6760 clk|done|rst_n|sdi|sdo|sh_en|start
+ clk|done|rst_n|sdi|sdo|sh_en|start VSS INVR00
* cell instance $745 r0 *1 1055.1,835.4
X$745 \$I6760 clk|done|rst_n|sdi|sdo|sh_en|start
+ clk|done|rst_n|sdi|sdo|sh_en|start VSS INVR00
* cell instance $746 r0 *1 392.1,632.6
X$746 \$I6781 clk|done|rst_n|sdi|sdo|sh_en|start
+ clk|done|rst_n|sdi|sdo|sh_en|start VSS INVR00
* cell instance $747 r0 *1 1140.9,1545.2
X$747 \$I6832 clk|done|rst_n|sdi|sdo|sh_en|start
+ clk|done|rst_n|sdi|sdo|sh_en|start VSS INVR00
* cell instance $748 r0 *1 1332,936.8
X$748 \$I6730 clk|done|rst_n|sdi|sdo|sh_en|start
+ clk|done|rst_n|sdi|sdo|sh_en|start VSS INVR00
* cell instance $749 r0 *1 540.3,1443.8
X$749 \$I6819 \$2382 clk|done|rst_n|sdi|sdo|sh_en|start VSS INVR00
* cell instance $750 r0 *1 571.5,1038.2
X$750 \$I6775 clk|done|rst_n|sdi|sdo|sh_en|start
+ clk|done|rst_n|sdi|sdo|sh_en|start VSS INVR00
* cell instance $751 r0 *1 1031.7,1241
X$751 \$I6818 clk|done|rst_n|sdi|sdo|sh_en|start
+ clk|done|rst_n|sdi|sdo|sh_en|start VSS INVR00
* cell instance $752 r0 *1 622.2,1545.2
X$752 \$I6832 clk|done|rst_n|sdi|sdo|sh_en|start
+ clk|done|rst_n|sdi|sdo|sh_en|start VSS INVR00
* cell instance $753 r0 *1 672.9,734
X$753 \$I2783 clk|done|rst_n|sdi|sdo|sh_en|start
+ clk|done|rst_n|sdi|sdo|sh_en|start VSS INVR00
* cell instance $754 r0 *1 341.4,1393.1
X$754 \$I6830 \$2227 clk|done|rst_n|sdi|sdo|sh_en|start VSS INVR00
* cell instance $755 r0 *1 591,1038.2
X$755 \$I6775 \$1456 clk|done|rst_n|sdi|sdo|sh_en|start VSS INVR00
* cell instance $756 r0 *1 688.5,734
X$756 \$I2783 clk|done|rst_n|sdi|sdo|sh_en|start
+ clk|done|rst_n|sdi|sdo|sh_en|start VSS INVR00
* cell instance $757 r0 *1 758.7,734
X$757 \$I2783 clk|done|rst_n|sdi|sdo|sh_en|start
+ clk|done|rst_n|sdi|sdo|sh_en|start VSS INVR00
* cell instance $758 r0 *1 540.3,379.1
X$758 \$I2572 \$96 clk|done|rst_n|sdi|sdo|sh_en|start VSS INVR00
* cell instance $759 r0 *1 559.8,531.2
X$759 \$I2745 clk|done|rst_n|sdi|sdo|sh_en|start
+ clk|done|rst_n|sdi|sdo|sh_en|start VSS INVR00
* cell instance $760 r0 *1 825,1038.2
X$760 \$I6775 \$1461 clk|done|rst_n|sdi|sdo|sh_en|start VSS INVR00
* cell instance $761 r0 *1 438.9,1443.8
X$761 \$I6819 \$2347 clk|done|rst_n|sdi|sdo|sh_en|start VSS INVR00
* cell instance $762 r0 *1 1437.3,886.1
X$762 \$I6796 \$1181 clk|done|rst_n|sdi|sdo|sh_en|start VSS INVR00
* cell instance $763 r0 *1 1421.7,886.1
X$763 \$I6796 clk|done|rst_n|sdi|sdo|sh_en|start
+ clk|done|rst_n|sdi|sdo|sh_en|start VSS INVR00
* cell instance $764 r0 *1 1335.9,1241
X$764 \$I6818 clk|done|rst_n|sdi|sdo|sh_en|start
+ clk|done|rst_n|sdi|sdo|sh_en|start VSS INVR00
* cell instance $765 r0 *1 618.3,379.1
X$765 \$I2572 \$76 clk|done|rst_n|sdi|sdo|sh_en|start VSS INVR00
* cell instance $766 r0 *1 357,1545.2
X$766 \$I6832 \$2583 clk|done|rst_n|sdi|sdo|sh_en|start VSS INVR00
* cell instance $767 r0 *1 1308.6,1088.9
X$767 \$I6789 clk|done|rst_n|sdi|sdo|sh_en|start
+ clk|done|rst_n|sdi|sdo|sh_en|start VSS INVR00
* cell instance $768 r0 *1 708,480.5
X$768 \$I2747 clk|done|rst_n|sdi|sdo|sh_en|start
+ clk|done|rst_n|sdi|sdo|sh_en|start VSS INVR00
* cell instance $769 r0 *1 1265.7,987.5
X$769 \$I6725 clk|done|rst_n|sdi|sdo|sh_en|start
+ clk|done|rst_n|sdi|sdo|sh_en|start VSS INVR00
* cell instance $770 r0 *1 1207.2,987.5
X$770 \$I6725 clk|done|rst_n|sdi|sdo|sh_en|start
+ clk|done|rst_n|sdi|sdo|sh_en|start VSS INVR00
* cell instance $771 r0 *1 1152.6,1241
X$771 \$I6818 \$1855 clk|done|rst_n|sdi|sdo|sh_en|start VSS INVR00
* cell instance $772 r0 *1 1316.4,987.5
X$772 \$I6725 \$1307 clk|done|rst_n|sdi|sdo|sh_en|start VSS INVR00
* cell instance $773 r0 *1 1261.8,1241
X$773 \$I6818 clk|done|rst_n|sdi|sdo|sh_en|start
+ clk|done|rst_n|sdi|sdo|sh_en|start VSS INVR00
* cell instance $774 r0 *1 1343.7,1088.9
X$774 \$I6789 clk|done|rst_n|sdi|sdo|sh_en|start
+ clk|done|rst_n|sdi|sdo|sh_en|start VSS INVR00
* cell instance $775 r0 *1 965.4,429.8
X$775 \$I2762 clk|done|rst_n|sdi|sdo|sh_en|start
+ clk|done|rst_n|sdi|sdo|sh_en|start VSS INVR00
* cell instance $776 r0 *1 1086.3,987.5
X$776 \$I6725 clk|done|rst_n|sdi|sdo|sh_en|start
+ clk|done|rst_n|sdi|sdo|sh_en|start VSS INVR00
* cell instance $777 r0 *1 1004.4,480.5
X$777 \$I2747 \$352 clk|done|rst_n|sdi|sdo|sh_en|start VSS INVR00
* cell instance $778 r0 *1 337.5,987.5
X$778 \$I6725 \$1343 clk|done|rst_n|sdi|sdo|sh_en|start VSS INVR00
* cell instance $779 r0 *1 1078.5,1291.7
X$779 \$I6812 clk|done|rst_n|sdi|sdo|sh_en|start
+ clk|done|rst_n|sdi|sdo|sh_en|start VSS INVR00
* cell instance $780 r0 *1 431.1,581.9
X$780 \$I2828 \$434 clk|done|rst_n|sdi|sdo|sh_en|start VSS INVR00
* cell instance $781 r0 *1 1437.3,1342.4
X$781 \$I6823 clk|done|rst_n|sdi|sdo|sh_en|start
+ clk|done|rst_n|sdi|sdo|sh_en|start VSS INVR00
* cell instance $782 r0 *1 528.6,480.5
X$782 \$I2747 \$323 clk|done|rst_n|sdi|sdo|sh_en|start VSS INVR00
* cell instance $783 r0 *1 489.6,1038.2
X$783 \$I6775 \$1480 clk|done|rst_n|sdi|sdo|sh_en|start VSS INVR00
* cell instance $784 r0 *1 1312.5,1190.3
X$784 \$I6808 \$1715 clk|done|rst_n|sdi|sdo|sh_en|start VSS INVR00
* cell instance $785 r0 *1 501.3,480.5
X$785 \$I2747 \$271 clk|done|rst_n|sdi|sdo|sh_en|start VSS INVR00
* cell instance $786 r0 *1 1460.7,632.6
X$786 \$I6781 \$634 clk|done|rst_n|sdi|sdo|sh_en|start VSS INVR00
* cell instance $787 r0 *1 1012.2,632.6
X$787 \$I6781 \$565 clk|done|rst_n|sdi|sdo|sh_en|start VSS INVR00
* cell instance $788 r0 *1 419.4,480.5
X$788 \$I2747 clk|done|rst_n|sdi|sdo|sh_en|start
+ clk|done|rst_n|sdi|sdo|sh_en|start VSS INVR00
* cell instance $789 r0 *1 1351.5,1038.2
X$789 \$I6775 \$1519 clk|done|rst_n|sdi|sdo|sh_en|start VSS INVR00
* cell instance $790 r0 *1 747,886.1
X$790 \$I6796 clk|done|rst_n|sdi|sdo|sh_en|start
+ clk|done|rst_n|sdi|sdo|sh_en|start VSS INVR00
* cell instance $791 r0 *1 321.9,1190.3
X$791 \$1745 clk|done|rst_n|sdi|sdo|sh_en|start
+ clk|done|rst_n|sdi|sdo|sh_en|start \$I10010 \$I6808 VSS DFFL11
* cell instance $792 r0 *1 1191.6,1190.3
X$792 clk|done|rst_n|sdi|sdo|sh_en|start clk|done|rst_n|sdi|sdo|sh_en|start
+ clk|done|rst_n|sdi|sdo|sh_en|start \$1905 \$I6808 VSS DFFL11
* cell instance $793 r0 *1 1464.6,784.7
X$793 clk|done|rst_n|sdi|sdo|sh_en|start clk|done|rst_n|sdi|sdo|sh_en|start
+ clk|done|rst_n|sdi|sdo|sh_en|start \$I10005 \$I2758 VSS DFFL11
* cell instance $794 r0 *1 1460.7,683.3
X$794 clk|done|rst_n|sdi|sdo|sh_en|start clk|done|rst_n|sdi|sdo|sh_en|start
+ clk|done|rst_n|sdi|sdo|sh_en|start \$I10004 \$I6788 VSS DFFL11
* cell instance $795 r0 *1 1456.8,936.8
X$795 clk|done|rst_n|sdi|sdo|sh_en|start clk|done|rst_n|sdi|sdo|sh_en|start
+ clk|done|rst_n|sdi|sdo|sh_en|start \$I10003 \$I6730 VSS DFFL11
* cell instance $796 r0 *1 493.5,1393.1
X$796 clk|done|rst_n|sdi|sdo|sh_en|start clk|done|rst_n|sdi|sdo|sh_en|start
+ clk|done|rst_n|sdi|sdo|sh_en|start \$I9999 \$I6830 VSS DFFL11
* cell instance $797 r0 *1 442.8,531.2
X$797 clk|done|rst_n|sdi|sdo|sh_en|start clk|done|rst_n|sdi|sdo|sh_en|start
+ clk|done|rst_n|sdi|sdo|sh_en|start \$I9997 \$I2745 VSS DFFL11
* cell instance $798 r0 *1 1417.8,734
X$798 clk|done|rst_n|sdi|sdo|sh_en|start clk|done|rst_n|sdi|sdo|sh_en|start
+ clk|done|rst_n|sdi|sdo|sh_en|start \$I9995 \$I2783 VSS DFFL11
* cell instance $799 r0 *1 466.2,1545.2
X$799 clk|done|rst_n|sdi|sdo|sh_en|start clk|done|rst_n|sdi|sdo|sh_en|start
+ clk|done|rst_n|sdi|sdo|sh_en|start \$I9989 \$I6832 VSS DFFL11
* cell instance $800 r0 *1 1152.6,581.9
X$800 clk|done|rst_n|sdi|sdo|sh_en|start clk|done|rst_n|sdi|sdo|sh_en|start
+ clk|done|rst_n|sdi|sdo|sh_en|start \$I9986 \$I2828 VSS DFFL11
* cell instance $801 r0 *1 1558.2,581.9
X$801 clk|done|rst_n|sdi|sdo|sh_en|start clk|done|rst_n|sdi|sdo|sh_en|start
+ clk|done|rst_n|sdi|sdo|sh_en|start \$I9984 \$I2828 VSS DFFL11
* cell instance $802 r0 *1 988.8,987.5
X$802 clk|done|rst_n|sdi|sdo|sh_en|start clk|done|rst_n|sdi|sdo|sh_en|start
+ clk|done|rst_n|sdi|sdo|sh_en|start \$I9981 \$I6725 VSS DFFL11
* cell instance $803 r0 *1 1616.7,734
X$803 clk|done|rst_n|sdi|sdo|sh_en|start clk|done|rst_n|sdi|sdo|sh_en|start
+ clk|done|rst_n|sdi|sdo|sh_en|start \$I9980 \$I2783 VSS DFFL11
* cell instance $804 r0 *1 676.8,936.8
X$804 clk|done|rst_n|sdi|sdo|sh_en|start clk|done|rst_n|sdi|sdo|sh_en|start
+ clk|done|rst_n|sdi|sdo|sh_en|start \$I9976 \$I6730 VSS DFFL11
* cell instance $805 r0 *1 544.2,683.3
X$805 clk|done|rst_n|sdi|sdo|sh_en|start clk|done|rst_n|sdi|sdo|sh_en|start
+ clk|done|rst_n|sdi|sdo|sh_en|start \$I9975 \$I6788 VSS DFFL11
* cell instance $806 r0 *1 813.3,328.4
X$806 clk|done|rst_n|sdi|sdo|sh_en|start clk|done|rst_n|sdi|sdo|sh_en|start
+ clk|done|rst_n|sdi|sdo|sh_en|start \$I9974 \$I2245 VSS DFFL11
* cell instance $807 r0 *1 786,581.9
X$807 \$555 clk|done|rst_n|sdi|sdo|sh_en|start
+ clk|done|rst_n|sdi|sdo|sh_en|start \$I9972 \$I2828 VSS DFFL11
* cell instance $808 r0 *1 778.2,429.8
X$808 clk|done|rst_n|sdi|sdo|sh_en|start clk|done|rst_n|sdi|sdo|sh_en|start
+ clk|done|rst_n|sdi|sdo|sh_en|start \$I9971 \$I2762 VSS DFFL11
* cell instance $809 r0 *1 696.3,1088.9
X$809 clk|done|rst_n|sdi|sdo|sh_en|start clk|done|rst_n|sdi|sdo|sh_en|start
+ clk|done|rst_n|sdi|sdo|sh_en|start \$I9964 \$I6789 VSS DFFL11
* cell instance $810 r0 *1 1218.9,379.1
X$810 clk|done|rst_n|sdi|sdo|sh_en|start clk|done|rst_n|sdi|sdo|sh_en|start
+ clk|done|rst_n|sdi|sdo|sh_en|start \$I9955 \$I2572 VSS DFFL11
* cell instance $811 r0 *1 1324.2,328.4
X$811 clk|done|rst_n|sdi|sdo|sh_en|start clk|done|rst_n|sdi|sdo|sh_en|start
+ clk|done|rst_n|sdi|sdo|sh_en|start \$I9954 \$I2245 VSS DFFL11
* cell instance $812 r0 *1 1616.7,632.6
X$812 clk|done|rst_n|sdi|sdo|sh_en|start clk|done|rst_n|sdi|sdo|sh_en|start
+ clk|done|rst_n|sdi|sdo|sh_en|start \$I9951 \$I6781 VSS DFFL11
* cell instance $813 r0 *1 493.5,1342.4
X$813 clk|done|rst_n|sdi|sdo|sh_en|start clk|done|rst_n|sdi|sdo|sh_en|start
+ clk|done|rst_n|sdi|sdo|sh_en|start \$I9949 \$I6823 VSS DFFL11
* cell instance $814 r0 *1 431.1,480.5
X$814 clk|done|rst_n|sdi|sdo|sh_en|start clk|done|rst_n|sdi|sdo|sh_en|start
+ clk|done|rst_n|sdi|sdo|sh_en|start \$I9943 \$I2747 VSS DFFL11
* cell instance $815 r0 *1 914.7,328.4
X$815 clk|done|rst_n|sdi|sdo|sh_en|start clk|done|rst_n|sdi|sdo|sh_en|start
+ clk|done|rst_n|sdi|sdo|sh_en|start \$I9942 \$I2245 VSS DFFL11
* cell instance $816 r0 *1 700.2,835.4
X$816 clk|done|rst_n|sdi|sdo|sh_en|start clk|done|rst_n|sdi|sdo|sh_en|start
+ clk|done|rst_n|sdi|sdo|sh_en|start \$I9938 \$I6760 VSS DFFL11
* cell instance $817 r0 *1 1335.9,632.6
X$817 clk|done|rst_n|sdi|sdo|sh_en|start clk|done|rst_n|sdi|sdo|sh_en|start
+ clk|done|rst_n|sdi|sdo|sh_en|start \$I9936 \$I6781 VSS DFFL11
* cell instance $818 r0 *1 669,683.3
X$818 clk|done|rst_n|sdi|sdo|sh_en|start clk|done|rst_n|sdi|sdo|sh_en|start
+ clk|done|rst_n|sdi|sdo|sh_en|start \$I9934 \$I6788 VSS DFFL11
* cell instance $819 r0 *1 1616.7,936.8
X$819 clk|done|rst_n|sdi|sdo|sh_en|start clk|done|rst_n|sdi|sdo|sh_en|start
+ clk|done|rst_n|sdi|sdo|sh_en|start \$I9933 \$I6730 VSS DFFL11
* cell instance $820 r0 *1 1082.4,1393.1
X$820 clk|done|rst_n|sdi|sdo|sh_en|start clk|done|rst_n|sdi|sdo|sh_en|start
+ clk|done|rst_n|sdi|sdo|sh_en|start \$2370 \$I6830 VSS DFFL11
* cell instance $821 r0 *1 598.8,1494.5
X$821 clk|done|rst_n|sdi|sdo|sh_en|start clk|done|rst_n|sdi|sdo|sh_en|start
+ clk|done|rst_n|sdi|sdo|sh_en|start \$I9928 \$I6833 VSS DFFL11
* cell instance $822 r0 *1 719.7,784.7
X$822 clk|done|rst_n|sdi|sdo|sh_en|start clk|done|rst_n|sdi|sdo|sh_en|start
+ clk|done|rst_n|sdi|sdo|sh_en|start \$I9926 \$I2758 VSS DFFL11
* cell instance $823 r0 *1 1012.2,683.3
X$823 clk|done|rst_n|sdi|sdo|sh_en|start clk|done|rst_n|sdi|sdo|sh_en|start
+ clk|done|rst_n|sdi|sdo|sh_en|start \$I9924 \$I6788 VSS DFFL11
* cell instance $824 r0 *1 524.7,936.8
X$824 clk|done|rst_n|sdi|sdo|sh_en|start clk|done|rst_n|sdi|sdo|sh_en|start
+ clk|done|rst_n|sdi|sdo|sh_en|start \$I9923 \$I6730 VSS DFFL11
* cell instance $825 r0 *1 1597.2,886.1
X$825 clk|done|rst_n|sdi|sdo|sh_en|start clk|done|rst_n|sdi|sdo|sh_en|start
+ clk|done|rst_n|sdi|sdo|sh_en|start \$I9920 \$I6796 VSS DFFL11
* cell instance $826 r0 *1 817.2,835.4
X$826 clk|done|rst_n|sdi|sdo|sh_en|start clk|done|rst_n|sdi|sdo|sh_en|start
+ clk|done|rst_n|sdi|sdo|sh_en|start \$I9919 \$I6760 VSS DFFL11
* cell instance $827 r0 *1 1437.3,429.8
X$827 clk|done|rst_n|sdi|sdo|sh_en|start clk|done|rst_n|sdi|sdo|sh_en|start
+ clk|done|rst_n|sdi|sdo|sh_en|start \$I9914 \$I2762 VSS DFFL11
* cell instance $828 r0 *1 906.9,734
X$828 clk|done|rst_n|sdi|sdo|sh_en|start clk|done|rst_n|sdi|sdo|sh_en|start
+ clk|done|rst_n|sdi|sdo|sh_en|start \$I9907 \$I2783 VSS DFFL11
* cell instance $829 r0 *1 1542.6,936.8
X$829 clk|done|rst_n|sdi|sdo|sh_en|start clk|done|rst_n|sdi|sdo|sh_en|start
+ clk|done|rst_n|sdi|sdo|sh_en|start \$I9905 \$I6730 VSS DFFL11
* cell instance $830 r0 *1 1425.6,835.4
X$830 clk|done|rst_n|sdi|sdo|sh_en|start clk|done|rst_n|sdi|sdo|sh_en|start
+ clk|done|rst_n|sdi|sdo|sh_en|start \$I9904 \$I6760 VSS DFFL11
* cell instance $831 r0 *1 1480.2,379.1
X$831 clk|done|rst_n|sdi|sdo|sh_en|start clk|done|rst_n|sdi|sdo|sh_en|start
+ clk|done|rst_n|sdi|sdo|sh_en|start \$I9900 \$I2572 VSS DFFL11
* cell instance $832 r0 *1 930.3,835.4
X$832 clk|done|rst_n|sdi|sdo|sh_en|start clk|done|rst_n|sdi|sdo|sh_en|start
+ clk|done|rst_n|sdi|sdo|sh_en|start \$I9898 \$I6760 VSS DFFL11
* cell instance $833 r0 *1 524.7,581.9
X$833 clk|done|rst_n|sdi|sdo|sh_en|start clk|done|rst_n|sdi|sdo|sh_en|start
+ clk|done|rst_n|sdi|sdo|sh_en|start \$I9897 \$I2828 VSS DFFL11
* cell instance $834 r0 *1 708,632.6
X$834 clk|done|rst_n|sdi|sdo|sh_en|start clk|done|rst_n|sdi|sdo|sh_en|start
+ clk|done|rst_n|sdi|sdo|sh_en|start \$I9896 \$I6781 VSS DFFL11
* cell instance $835 r0 *1 325.8,632.6
X$835 clk|done|rst_n|sdi|sdo|sh_en|start clk|done|rst_n|sdi|sdo|sh_en|start
+ clk|done|rst_n|sdi|sdo|sh_en|start \$I9895 \$I6781 VSS DFFL11
* cell instance $836 r0 *1 1183.8,734
X$836 clk|done|rst_n|sdi|sdo|sh_en|start clk|done|rst_n|sdi|sdo|sh_en|start
+ clk|done|rst_n|sdi|sdo|sh_en|start \$I9894 \$I2783 VSS DFFL11
* cell instance $837 r0 *1 614.4,886.1
X$837 clk|done|rst_n|sdi|sdo|sh_en|start clk|done|rst_n|sdi|sdo|sh_en|start
+ clk|done|rst_n|sdi|sdo|sh_en|start \$I9893 \$I6796 VSS DFFL11
* cell instance $838 r0 *1 372.6,531.2
X$838 clk|done|rst_n|sdi|sdo|sh_en|start clk|done|rst_n|sdi|sdo|sh_en|start
+ clk|done|rst_n|sdi|sdo|sh_en|start \$I9890 \$I2745 VSS DFFL11
* cell instance $839 r0 *1 606.6,734
X$839 clk|done|rst_n|sdi|sdo|sh_en|start clk|done|rst_n|sdi|sdo|sh_en|start
+ clk|done|rst_n|sdi|sdo|sh_en|start \$I9888 \$I2783 VSS DFFL11
* cell instance $840 r0 *1 1000.5,734
X$840 clk|done|rst_n|sdi|sdo|sh_en|start clk|done|rst_n|sdi|sdo|sh_en|start
+ clk|done|rst_n|sdi|sdo|sh_en|start \$I9887 \$I2783 VSS DFFL11
* cell instance $841 r0 *1 641.7,480.5
X$841 clk|done|rst_n|sdi|sdo|sh_en|start clk|done|rst_n|sdi|sdo|sh_en|start
+ clk|done|rst_n|sdi|sdo|sh_en|start \$I9886 \$I2747 VSS DFFL11
* cell instance $842 r0 *1 1402.2,328.4
X$842 clk|done|rst_n|sdi|sdo|sh_en|start clk|done|rst_n|sdi|sdo|sh_en|start
+ clk|done|rst_n|sdi|sdo|sh_en|start \$I9881 \$I2245 VSS DFFL11
* cell instance $843 r0 *1 1417.8,531.2
X$843 clk|done|rst_n|sdi|sdo|sh_en|start clk|done|rst_n|sdi|sdo|sh_en|start
+ clk|done|rst_n|sdi|sdo|sh_en|start \$I9880 \$I2745 VSS DFFL11
* cell instance $844 r0 *1 1027.8,784.7
X$844 clk|done|rst_n|sdi|sdo|sh_en|start clk|done|rst_n|sdi|sdo|sh_en|start
+ clk|done|rst_n|sdi|sdo|sh_en|start \$I9879 \$I2758 VSS DFFL11
* cell instance $845 r0 *1 353.1,1241
X$845 \$I6818 clk|done|rst_n|sdi|sdo|sh_en|start \$1788 VSS INVR00
* cell instance $846 r0 *1 1449,480.5
X$846 \$I2747 clk|done|rst_n|sdi|sdo|sh_en|start \$366 VSS INVR00
* cell instance $847 r0 *1 587.1,632.6
X$847 \$I6781 clk|done|rst_n|sdi|sdo|sh_en|start \$653 VSS INVR00
* cell instance $848 r0 *1 481.8,1393.1
X$848 \$I6830 clk|done|rst_n|sdi|sdo|sh_en|start \$2231 VSS INVR00
* cell instance $849 r0 *1 544.2,1088.9
X$849 \$I6789 clk|done|rst_n|sdi|sdo|sh_en|start \$1395 VSS INVR00
* cell instance $850 r0 *1 532.5,1545.2
X$850 \$I6832 clk|done|rst_n|sdi|sdo|sh_en|start \$2588 VSS INVR00
* cell instance $851 r0 *1 735.3,683.3
X$851 \$I6788 clk|done|rst_n|sdi|sdo|sh_en|start \$760 VSS INVR00
* cell instance $852 r0 *1 329.7,531.2
X$852 \$I2745 clk|done|rst_n|sdi|sdo|sh_en|start \$300 VSS INVR00
* cell instance $853 r0 *1 665.1,936.8
X$853 \$I6730 clk|done|rst_n|sdi|sdo|sh_en|start \$1288 VSS INVR00
* cell instance $854 r0 *1 474,1291.7
X$854 \$I6812 clk|done|rst_n|sdi|sdo|sh_en|start \$2022 VSS INVR00
* cell instance $855 r0 *1 1230.6,328.4
X$855 clk|done|rst_n|sdi|sdo|sh_en|start clk|done|rst_n|sdi|sdo|sh_en|start
+ \$15 \$I10011 \$I2245 VSS DFFL11
* cell instance $856 r0 *1 1449,886.1
X$856 clk|done|rst_n|sdi|sdo|sh_en|start clk|done|rst_n|sdi|sdo|sh_en|start
+ \$1181 \$I10008 \$I6796 VSS DFFL11
* cell instance $857 r0 *1 992.7,886.1
X$857 clk|done|rst_n|sdi|sdo|sh_en|start clk|done|rst_n|sdi|sdo|sh_en|start
+ \$1269 \$I10002 \$I6796 VSS DFFL11
* cell instance $858 r0 *1 415.5,1393.1
X$858 clk|done|rst_n|sdi|sdo|sh_en|start clk|done|rst_n|sdi|sdo|sh_en|start
+ \$2347 \$I10001 \$I6830 VSS DFFL11
* cell instance $859 r0 *1 321.9,784.7
X$859 clk|done|rst_n|sdi|sdo|sh_en|start clk|done|rst_n|sdi|sdo|sh_en|start
+ \$1034 \$I9994 \$I2758 VSS DFFL11
* cell instance $860 r0 *1 392.1,683.3
X$860 clk|done|rst_n|sdi|sdo|sh_en|start clk|done|rst_n|sdi|sdo|sh_en|start
+ \$753 \$I9993 \$I6788 VSS DFFL11
* cell instance $861 r0 *1 555.9,480.5
X$861 clk|done|rst_n|sdi|sdo|sh_en|start clk|done|rst_n|sdi|sdo|sh_en|start
+ \$323 \$I9991 \$I2747 VSS DFFL11
* cell instance $862 r0 *1 548.1,1545.2
X$862 clk|done|rst_n|sdi|sdo|sh_en|start clk|done|rst_n|sdi|sdo|sh_en|start
+ \$2639 \$I9990 \$I6832 VSS DFFL11
* cell instance $863 r0 *1 532.5,1494.5
X$863 clk|done|rst_n|sdi|sdo|sh_en|start clk|done|rst_n|sdi|sdo|sh_en|start
+ \$2382 \$I9988 \$I6833 VSS DFFL11
* cell instance $864 r0 *1 321.9,734
X$864 clk|done|rst_n|sdi|sdo|sh_en|start clk|done|rst_n|sdi|sdo|sh_en|start
+ \$749 \$I9985 \$I2783 VSS DFFL11
* cell instance $865 r0 *1 1616.7,1088.9
X$865 clk|done|rst_n|sdi|sdo|sh_en|start clk|done|rst_n|sdi|sdo|sh_en|start
+ \$1724 \$I9983 \$I6789 VSS DFFL11
* cell instance $866 r0 *1 774.3,987.5
X$866 clk|done|rst_n|sdi|sdo|sh_en|start clk|done|rst_n|sdi|sdo|sh_en|start
+ \$1461 \$I9982 \$I6725 VSS DFFL11
* cell instance $867 r0 *1 1152.6,328.4
X$867 clk|done|rst_n|sdi|sdo|sh_en|start clk|done|rst_n|sdi|sdo|sh_en|start
+ \$48 \$I9977 \$I2245 VSS DFFL11
* cell instance $868 r0 *1 1226.7,480.5
X$868 clk|done|rst_n|sdi|sdo|sh_en|start clk|done|rst_n|sdi|sdo|sh_en|start
+ \$252 \$I9973 \$I2747 VSS DFFL11
* cell instance $869 r0 *1 1616.7,531.2
X$869 clk|done|rst_n|sdi|sdo|sh_en|start clk|done|rst_n|sdi|sdo|sh_en|start
+ \$376 \$I9970 \$I2745 VSS DFFL11
* cell instance $870 r0 *1 926.4,936.8
X$870 clk|done|rst_n|sdi|sdo|sh_en|start clk|done|rst_n|sdi|sdo|sh_en|start
+ \$1162 \$I9968 \$I6730 VSS DFFL11
* cell instance $871 r0 *1 435,1241
X$871 clk|done|rst_n|sdi|sdo|sh_en|start clk|done|rst_n|sdi|sdo|sh_en|start
+ \$1918 \$I9965 \$I6818 VSS DFFL11
* cell instance $872 r0 *1 466.2,1088.9
X$872 clk|done|rst_n|sdi|sdo|sh_en|start clk|done|rst_n|sdi|sdo|sh_en|start
+ \$1480 \$I9963 \$I6789 VSS DFFL11
* cell instance $873 r0 *1 672.9,987.5
X$873 clk|done|rst_n|sdi|sdo|sh_en|start clk|done|rst_n|sdi|sdo|sh_en|start
+ \$1459 \$I9962 \$I6725 VSS DFFL11
* cell instance $874 r0 *1 509.1,328.4
X$874 clk|done|rst_n|sdi|sdo|sh_en|start clk|done|rst_n|sdi|sdo|sh_en|start \$9
+ \$I9960 \$I2245 VSS DFFL11
* cell instance $875 r0 *1 392.1,1088.9
X$875 clk|done|rst_n|sdi|sdo|sh_en|start clk|done|rst_n|sdi|sdo|sh_en|start
+ \$1694 \$I9959 \$I6789 VSS DFFL11
* cell instance $876 r0 *1 758.7,379.1
X$876 clk|done|rst_n|sdi|sdo|sh_en|start clk|done|rst_n|sdi|sdo|sh_en|start
+ \$208 \$I9958 \$I2572 VSS DFFL11
* cell instance $877 r0 *1 1616.7,987.5
X$877 clk|done|rst_n|sdi|sdo|sh_en|start clk|done|rst_n|sdi|sdo|sh_en|start
+ \$1534 \$I9956 \$I6725 VSS DFFL11
* cell instance $878 r0 *1 1293,734
X$878 clk|done|rst_n|sdi|sdo|sh_en|start clk|done|rst_n|sdi|sdo|sh_en|start
+ \$953 \$I9953 \$I2783 VSS DFFL11
* cell instance $879 r0 *1 321.9,936.8
X$879 clk|done|rst_n|sdi|sdo|sh_en|start clk|done|rst_n|sdi|sdo|sh_en|start
+ \$1343 \$I9952 \$I6730 VSS DFFL11
* cell instance $880 r0 *1 524.7,1241
X$880 clk|done|rst_n|sdi|sdo|sh_en|start clk|done|rst_n|sdi|sdo|sh_en|start
+ \$1921 \$I9950 \$I6818 VSS DFFL11
* cell instance $881 r0 *1 333.6,1494.5
X$881 clk|done|rst_n|sdi|sdo|sh_en|start clk|done|rst_n|sdi|sdo|sh_en|start
+ \$2583 \$I9948 \$I6833 VSS DFFL11
* cell instance $882 r0 *1 1542.6,734
X$882 clk|done|rst_n|sdi|sdo|sh_en|start clk|done|rst_n|sdi|sdo|sh_en|start
+ \$845 \$I9946 \$I2783 VSS DFFL11
* cell instance $883 r0 *1 895.2,480.5
X$883 clk|done|rst_n|sdi|sdo|sh_en|start clk|done|rst_n|sdi|sdo|sh_en|start
+ \$424 \$I9945 \$I2747 VSS DFFL11
* cell instance $884 r0 *1 540.3,734
X$884 clk|done|rst_n|sdi|sdo|sh_en|start clk|done|rst_n|sdi|sdo|sh_en|start
+ \$756 \$I9944 \$I2783 VSS DFFL11
* cell instance $885 r0 *1 598.8,987.5
X$885 clk|done|rst_n|sdi|sdo|sh_en|start clk|done|rst_n|sdi|sdo|sh_en|start
+ \$1349 \$I9941 \$I6725 VSS DFFL11
* cell instance $886 r0 *1 782.1,531.2
X$886 clk|done|rst_n|sdi|sdo|sh_en|start clk|done|rst_n|sdi|sdo|sh_en|start
+ \$345 \$I9940 \$I2745 VSS DFFL11
* cell instance $887 r0 *1 1616.7,1190.3
X$887 clk|done|rst_n|sdi|sdo|sh_en|start clk|done|rst_n|sdi|sdo|sh_en|start
+ \$1949 \$I9930 \$I6808 VSS DFFL11
* cell instance $888 r0 *1 435,987.5
X$888 clk|done|rst_n|sdi|sdo|sh_en|start clk|done|rst_n|sdi|sdo|sh_en|start
+ \$1448 \$I9927 \$I6725 VSS DFFL11
* cell instance $889 r0 *1 813.3,734
X$889 clk|done|rst_n|sdi|sdo|sh_en|start clk|done|rst_n|sdi|sdo|sh_en|start
+ \$971 \$I9925 \$I2783 VSS DFFL11
* cell instance $890 r0 *1 626.1,1190.3
X$890 clk|done|rst_n|sdi|sdo|sh_en|start clk|done|rst_n|sdi|sdo|sh_en|start
+ \$1923 \$I9922 \$I6808 VSS DFFL11
* cell instance $891 r0 *1 1429.5,581.9
X$891 clk|done|rst_n|sdi|sdo|sh_en|start clk|done|rst_n|sdi|sdo|sh_en|start
+ \$634 \$I9921 \$I2828 VSS DFFL11
* cell instance $892 r0 *1 481.8,1190.3
X$892 clk|done|rst_n|sdi|sdo|sh_en|start clk|done|rst_n|sdi|sdo|sh_en|start
+ \$1821 \$I9918 \$I6808 VSS DFFL11
* cell instance $893 r0 *1 1055.1,886.1
X$893 clk|done|rst_n|sdi|sdo|sh_en|start clk|done|rst_n|sdi|sdo|sh_en|start
+ \$1296 \$I9917 \$I6796 VSS DFFL11
* cell instance $894 r0 *1 1066.8,734
X$894 clk|done|rst_n|sdi|sdo|sh_en|start clk|done|rst_n|sdi|sdo|sh_en|start
+ \$774 \$I9916 \$I2783 VSS DFFL11
* cell instance $895 r0 *1 1398.3,1190.3
X$895 clk|done|rst_n|sdi|sdo|sh_en|start clk|done|rst_n|sdi|sdo|sh_en|start
+ \$1861 \$I9913 \$I6808 VSS DFFL11
* cell instance $896 r0 *1 708,531.2
X$896 clk|done|rst_n|sdi|sdo|sh_en|start clk|done|rst_n|sdi|sdo|sh_en|start
+ \$525 \$I9912 \$I2745 VSS DFFL11
* cell instance $897 r0 *1 591,328.4
X$897 clk|done|rst_n|sdi|sdo|sh_en|start clk|done|rst_n|sdi|sdo|sh_en|start
+ \$76 \$I9911 \$I2245 VSS DFFL11
* cell instance $898 r0 *1 996.6,429.8
X$898 clk|done|rst_n|sdi|sdo|sh_en|start clk|done|rst_n|sdi|sdo|sh_en|start
+ \$352 \$I9910 \$I2762 VSS DFFL11
* cell instance $899 r0 *1 1074.6,328.4
X$899 clk|done|rst_n|sdi|sdo|sh_en|start clk|done|rst_n|sdi|sdo|sh_en|start
+ \$83 \$I9908 \$I2245 VSS DFFL11
* cell instance $900 r0 *1 1530.9,429.8
X$900 clk|done|rst_n|sdi|sdo|sh_en|start clk|done|rst_n|sdi|sdo|sh_en|start
+ \$318 \$I9906 \$I2762 VSS DFFL11
* cell instance $901 r0 *1 321.9,1342.4
X$901 clk|done|rst_n|sdi|sdo|sh_en|start clk|done|rst_n|sdi|sdo|sh_en|start
+ \$2227 \$I9903 \$I6823 VSS DFFL11
* cell instance $902 r0 *1 325.8,1291.7
X$902 clk|done|rst_n|sdi|sdo|sh_en|start clk|done|rst_n|sdi|sdo|sh_en|start
+ \$2014 \$I9902 \$I6812 VSS DFFL11
* cell instance $903 r0 *1 462.3,683.3
X$903 clk|done|rst_n|sdi|sdo|sh_en|start clk|done|rst_n|sdi|sdo|sh_en|start
+ \$651 \$I9901 \$I6788 VSS DFFL11
* cell instance $904 r0 *1 996.6,328.4
X$904 clk|done|rst_n|sdi|sdo|sh_en|start clk|done|rst_n|sdi|sdo|sh_en|start
+ \$154 \$I9892 \$I2245 VSS DFFL11
* cell instance $905 r0 *1 645.6,531.2
X$905 clk|done|rst_n|sdi|sdo|sh_en|start clk|done|rst_n|sdi|sdo|sh_en|start
+ \$523 \$I9891 \$I2745 VSS DFFL11
* cell instance $906 r0 *1 321.9,581.9
X$906 clk|done|rst_n|sdi|sdo|sh_en|start clk|done|rst_n|sdi|sdo|sh_en|start
+ \$734 \$I9889 \$I2828 VSS DFFL11
* cell instance $907 r0 *1 996.6,531.2
X$907 clk|done|rst_n|sdi|sdo|sh_en|start clk|done|rst_n|sdi|sdo|sh_en|start
+ \$426 \$I9885 \$I2745 VSS DFFL11
* cell instance $908 r0 *1 906.9,632.6
X$908 clk|done|rst_n|sdi|sdo|sh_en|start clk|done|rst_n|sdi|sdo|sh_en|start
+ \$672 \$I9883 \$I6781 VSS DFFL11
* cell instance $909 r0 *1 1000.5,581.9
X$909 clk|done|rst_n|sdi|sdo|sh_en|start clk|done|rst_n|sdi|sdo|sh_en|start
+ \$565 \$I9882 \$I2828 VSS DFFL11
* cell instance $910 r0 *1 329.7,1038.2
X$910 \$1259 clk|done|rst_n|sdi|sdo|sh_en|start \$1345 \$I10000 \$I6775 VSS
+ DFFL11
* cell instance $911 r0 *1 450.6,835.4
X$911 \$1061 clk|done|rst_n|sdi|sdo|sh_en|start \$1129 \$I9992 \$I6760 VSS
+ DFFL11
* cell instance $912 r0 *1 1616.7,784.7
X$912 \$1032 clk|done|rst_n|sdi|sdo|sh_en|start \$1031 \$I9987 \$I2758 VSS
+ DFFL11
* cell instance $913 r0 *1 329.7,379.1
X$913 \$72 clk|done|rst_n|sdi|sdo|sh_en|start \$191 \$I9979 \$I2572 VSS DFFL11
* cell instance $914 r0 *1 364.8,886.1
X$914 \$1144 clk|done|rst_n|sdi|sdo|sh_en|start \$1147 \$I9966 \$I6796 VSS
+ DFFL11
* cell instance $915 r0 *1 321.9,1088.9
X$915 \$1623 clk|done|rst_n|sdi|sdo|sh_en|start \$1622 \$I9961 \$I6789 VSS
+ DFFL11
* cell instance $916 r0 *1 552,379.1
X$916 \$79 clk|done|rst_n|sdi|sdo|sh_en|start \$96 \$I9939 \$I2572 VSS DFFL11
* cell instance $917 r0 *1 509.1,987.5
X$917 \$1395 clk|done|rst_n|sdi|sdo|sh_en|start \$1450 \$I9909 \$I6725 VSS
+ DFFL11
* cell instance $918 r0 *1 680.7,328.4
X$918 \$28 clk|done|rst_n|sdi|sdo|sh_en|start \$11 \$I9899 \$I2245 VSS DFFL11
* cell instance $919 r0 *1 329.7,1443.8
X$919 \$2343 clk|done|rst_n|sdi|sdo|sh_en|start \$2380 \$I9884 \$I6819 VSS
+ DFFL11
* cell instance $4488 r0 *1 669,328.4
X$4488 \$I2245 \$11 \$7 VSS INVR00
* cell instance $4491 r0 *1 497.4,328.4
X$4491 \$I2245 \$9 \$8 VSS INVR00
* cell instance $4536 r0 *1 1234.5,429.8
X$4536 \$I2762 \$252 \$251 VSS INVR00
* cell instance $4582 r0 *1 345.3,683.3
X$4582 \$I6788 \$749 \$748 VSS INVR00
* cell instance $4587 r0 *1 380.4,683.3
X$4587 \$I6788 \$753 \$752 VSS INVR00
* cell instance $4612 r0 *1 345.3,835.4
X$4612 \$I6760 \$1034 \$1050 VSS INVR00
* cell instance $4622 r0 *1 438.9,886.1
X$4622 \$I6796 \$1097 \$1144 VSS INVR00
* cell instance $4629 r0 *1 454.5,886.1
X$4629 \$I6796 \$1147 \$1143 VSS INVR00
* cell instance $4645 r0 *1 587.1,987.5
X$4645 \$I6725 \$1349 \$1238 VSS INVR00
* cell instance $4648 r0 *1 1023.9,936.8
X$4648 \$I6730 \$1269 \$1244 VSS INVR00
* cell instance $4680 r0 *1 450.6,1038.2
X$4680 \$I6775 \$1448 \$1477 VSS INVR00
* cell instance $4683 r0 *1 524.7,1038.2
X$4683 \$I6775 \$1450 \$1452 VSS INVR00
* cell instance $4708 r0 *1 325.8,1139.6
X$4708 \$I6814 \$1622 \$1692 VSS INVR00
* cell instance $4713 r0 *1 1433.4,1088.9
X$4713 \$I6789 \$1655 \$1654 \$1718 VSS NOR200
* cell instance $4723 r0 *1 341.4,1139.6
X$4723 \$I6814 \$1694 \$1693 VSS INVR00
* cell instance $4748 r0 *1 501.3,1241
X$4748 \$I6818 \$1918 \$1893 VSS INVR00
* cell instance $4757 r0 *1 423.3,1291.7
X$4757 \$I6812 \$2014 \$2019 VSS INVR00
* cell instance $4764 r0 *1 1558.2,1291.7
X$4764 \$I6812 \$2053 \$2052 VSS INVR00
* cell instance $4788 r0 *1 454.5,1443.8
X$4788 \$I6819 \$2380 \$2345 VSS INVR00
* cell instance $4819 r0 *1 591,1595.9
X$4819 \$I6827 \$2639 \$2677 VSS INVR00
.ENDS tide_late

* cell frame2mmx2mm
* pin VDD
* pin PAD2_OUT
* pin PAD4_OUT
* pin PAD8_OUT
* pin PAD10_OUT
* pin PAD12_OUT
* pin PAD9
* pin PAD1
* pin GROUND
.SUBCKT frame2mmx2mm VDD PAD2_OUT PAD4_OUT PAD8_OUT PAD10_OUT PAD12_OUT PAD9
+ PAD1 GROUND
* cell instance $1 m135 *1 304.9,1605.8
X$1 VDD PAD11 GROUND ASPAD00
* cell instance $2 m135 *1 304.9,1201.2
X$2 GROUND PVSS01
* cell instance $3 m135 *1 304.9,851.2
X$3 VDD GROUND PVDD01
* cell instance $4 m0 *1 700.95,304.9
X$4 VDD PAD2 PAD2_OUT GROUND SPAD00
* cell instance $5 m0 *1 1400.95,304.9
X$5 VDD PAD4 PAD4_OUT GROUND SPAD00
* cell instance $6 r270 *1 1695.1,1605.8
X$6 VDD PAD6 PAD6_OUT GROUND SPAD00
* cell instance $7 r90 *1 304.9,350.95
X$7 VDD PAD12 PAD12_OUT GROUND SPAD00
* cell instance $8 r0 *1 1050.95,1695.1
X$8 VDD PAD8 PAD8_OUT GROUND SPAD00
* cell instance $9 r0 *1 350.95,1695.1
X$9 VDD PAD10 PAD10_OUT GROUND SPAD00
* cell instance $10 r270 *1 1695.1,1201.2
X$10 VDD GROUND PVDD01
* cell instance $11 r270 *1 1695.1,851.2
X$11 GROUND PVSS01
* cell instance $12 m45 *1 1695.1,350.95
X$12 VDD PAD5 GROUND ASPAD00
* cell instance $13 m0 *1 1050.95,304.9
X$13 VDD PAD3 GROUND ASPAD00
* cell instance $14 m0 *1 350.95,304.9
X$14 VDD PAD1 GROUND ASPAD00
* cell instance $15 r0 *1 700.95,1695.1
X$15 VDD PAD9 GROUND ASPAD00
* cell instance $16 r0 *1 1400.95,1695.1
X$16 VDD PAD7 GROUND ASPAD00
.ENDS frame2mmx2mm

* cell BUFF00
* pin VDD
* pin IN1
* pin OUT1
* pin GROUND
.SUBCKT BUFF00 VDD IN1 OUT1 GROUND
* device instance $1 r0 *1 4.3,5.4 N
M$1 GROUND IN1 \$2 GROUND N L=0.8U W=2U AS=7.76P AD=4.38P PS=11.4U PD=6.2U
* device instance $2 r0 *1 8.7,5.4 N
M$2 OUT1 \$2 GROUND GROUND N L=0.8U W=2U AS=4.38P AD=7.76P PS=6.2U PD=11.4U
* device instance $3 r0 *1 4.3,19.85 P
M$3 VDD IN1 \$2 VDD P L=0.8U W=3U AS=9.3P AD=5.595P PS=12.2U PD=6.8U
* device instance $4 r0 *1 8.7,19.95 P
M$4 OUT1 \$2 VDD VDD P L=0.8U W=3.2U AS=5.595P AD=9.92P PS=6.8U PD=12.6U
.ENDS BUFF00

* cell AND500
* pin IN1
* pin IN3
* pin IN2
* pin IN5
* pin IN4
* pin OUT1
* pin VDD
* pin GROUND
.SUBCKT AND500 IN1 IN3 IN2 IN5 IN4 OUT1 VDD GROUND
* device instance $1 r0 *1 4.4,4.65 N
M$1 \$8 IN5 GROUND GROUND N L=0.8U W=5.3U AS=15.37P AD=6.36P PS=16.4U PD=7.7U
* device instance $2 r0 *1 7.6,4.65 N
M$2 \$9 IN4 \$8 GROUND N L=0.8U W=5.3U AS=6.36P AD=8.215P PS=7.7U PD=8.4U
* device instance $3 r0 *1 11.5,4.65 N
M$3 \$10 IN3 \$9 GROUND N L=0.8U W=5.3U AS=8.215P AD=19.61P PS=8.4U PD=12.7U
* device instance $4 r0 *1 19.7,4.65 N
M$4 \$11 IN2 \$10 GROUND N L=0.8U W=5.3U AS=19.61P AD=3.445P PS=12.7U PD=6.6U
* device instance $5 r0 *1 21.8,4.65 N
M$5 \$12 IN1 \$11 GROUND N L=0.8U W=5.3U AS=3.445P AD=23.1P PS=6.6U PD=21.1U
* device instance $6 r0 *1 32,4.7 N
M$6 OUT1 \$12 GROUND GROUND N L=0.8U W=2U AS=7.76P AD=7.76P PS=11.4U PD=11.4U
* device instance $7 r0 *1 29.75,21.65 P
M$7 VDD \$12 OUT1 VDD P L=0.8U W=3U AS=8.7P AD=8.7P PS=11.8U PD=11.8U
* device instance $8 r0 *1 6.05,19.05 P
M$8 \$12 IN5 VDD VDD P L=0.8U W=6U AS=17.4P AD=9.6P PS=17.8U PD=9.2U
* device instance $9 r0 *1 10.05,19.05 P
M$9 VDD IN4 \$12 VDD P L=0.8U W=6U AS=9.6P AD=9.6P PS=9.2U PD=9.2U
* device instance $10 r0 *1 14.05,19.05 P
M$10 \$12 IN3 VDD VDD P L=0.8U W=6U AS=9.6P AD=11.1P PS=9.2U PD=9.7U
* device instance $11 r0 *1 18.55,19.05 P
M$11 VDD IN2 \$12 VDD P L=0.8U W=6U AS=11.1P AD=9.9P PS=9.7U PD=9.3U
* device instance $12 r0 *1 22.65,19.05 P
M$12 \$12 IN1 VDD VDD P L=0.8U W=6U AS=9.9P AD=17.4P PS=9.3U PD=17.8U
.ENDS AND500

* cell OR3100
* pin VDD
* pin OUT1
* pin IN3
* pin IN2
* pin IN1
* pin GROUND
.SUBCKT OR3100 VDD OUT1 IN3 IN2 IN1 GROUND
* device instance $1 r0 *1 4.25,4.4 N
M$1 \$2 IN1 GROUND GROUND N L=0.8U W=2.6U AS=7.54P AD=6.825P PS=11U PD=7.85U
* device instance $2 r0 *1 8.9,4.4 N
M$2 GROUND IN2 \$2 GROUND N L=0.8U W=2.6U AS=6.825P AD=4.16P PS=7.85U PD=5.8U
* device instance $3 r0 *1 12.9,4.4 N
M$3 \$2 IN3 GROUND GROUND N L=0.8U W=2.6U AS=4.16P AD=11.7P PS=5.8U PD=14.2U
* device instance $4 r0 *1 20.7,3.9 N
M$4 OUT1 \$2 GROUND GROUND N L=0.8U W=2U AS=7.76P AD=7.76P PS=11.4U PD=11.4U
* device instance $5 r0 *1 4.8,19.75 P
M$5 \$9 IN1 VDD VDD P L=0.8U W=8.5U AS=24.65P AD=8.5P PS=22.8U PD=10.5U
* device instance $6 r0 *1 7.6,19.75 P
M$6 \$8 IN2 \$9 VDD P L=0.8U W=8.5U AS=8.5P AD=11.2625P PS=10.5U PD=11.15U
* device instance $7 r0 *1 11.05,19.75 P
M$7 \$2 IN3 \$8 VDD P L=0.8U W=8.5U AS=11.2625P AD=32.3P PS=11.15U PD=24.6U
* device instance $8 r0 *1 20.05,19.15 P
M$8 OUT1 \$2 VDD VDD P L=0.8U W=3.1U AS=8.99P AD=8.99P PS=12U PD=12U
.ENDS OR3100

* cell AND400
* pin IN4
* pin IN2
* pin OUT1
* pin IN3
* pin IN1
* pin VDD
* pin GROUND
.SUBCKT AND400 IN4 IN2 OUT1 IN3 IN1 VDD GROUND
* device instance $1 r0 *1 8,5.25 N
M$1 \$6 IN4 GROUND GROUND N L=0.8U W=4.1U AS=11.89P AD=5.0225P PS=14U PD=6.55U
* device instance $2 r0 *1 11.25,5.25 N
M$2 \$7 IN3 \$6 GROUND N L=0.8U W=4.1U AS=5.0225P AD=7.6875P PS=6.55U PD=7.85U
* device instance $3 r0 *1 15.8,5.25 N
M$3 \$8 IN2 \$7 GROUND N L=0.8U W=4.1U AS=7.6875P AD=3.075P PS=7.85U PD=5.6U
* device instance $4 r0 *1 18.1,5.25 N
M$4 \$4 IN1 \$8 GROUND N L=0.8U W=4.1U AS=3.075P AD=13.53P PS=5.6U PD=14.8U
* device instance $5 r0 *1 26.6,3.5 N
M$5 OUT1 \$4 GROUND GROUND N L=0.8U W=2U AS=7.76P AD=7.76P PS=11.4U PD=11.4U
* device instance $6 r0 *1 6.15,18.45 P
M$6 VDD IN4 \$4 VDD P L=0.8U W=4.8U AS=13.92P AD=7.68P PS=15.4U PD=8U
* device instance $7 r0 *1 10.15,18.45 P
M$7 \$4 IN3 VDD VDD P L=0.8U W=4.8U AS=7.68P AD=7.68P PS=8U PD=8U
* device instance $8 r0 *1 14.15,18.45 P
M$8 VDD IN2 \$4 VDD P L=0.8U W=4.8U AS=7.68P AD=9.12P PS=8U PD=8.6U
* device instance $9 r0 *1 18.75,18.45 P
M$9 \$4 IN1 VDD VDD P L=0.8U W=4.8U AS=9.12P AD=13.92P PS=8.6U PD=15.4U
* device instance $10 r0 *1 26,20.85 P
M$10 VDD \$4 OUT1 VDD P L=0.8U W=3.3U AS=9.57P AD=9.57P PS=12.4U PD=12.4U
.ENDS AND400

* cell XNR200
* pin IN1
* pin OUT1
* pin IN2
* pin VDD
* pin GROUND
.SUBCKT XNR200 IN1 OUT1 IN2 VDD GROUND
* device instance $1 r0 *1 12.1,6 N
M$1 \$3 IN1 \$2 GROUND N L=0.8U W=2U AS=7.76P AD=4.38P PS=11.4U PD=6.2U
* device instance $2 r0 *1 16.5,6 N
M$2 \$4 \$6 \$3 GROUND N L=0.8U W=2U AS=4.38P AD=7.76P PS=6.2U PD=11.4U
* device instance $3 r0 *1 29.55,5.45 N
M$3 OUT1 \$3 GROUND GROUND N L=0.8U W=2U AS=7.76P AD=7.76P PS=11.4U PD=11.4U
* device instance $4 r0 *1 3.2,4.7 N
M$4 \$6 IN1 GROUND GROUND N L=0.8U W=2U AS=7.76P AD=7.76P PS=11.4U PD=11.4U
* device instance $5 r0 *1 37.35,4.4 N
M$5 \$2 IN2 GROUND GROUND N L=0.8U W=2U AS=8.02P AD=10.1P PS=11.6U PD=13.2U
* device instance $6 r0 *1 22.5,3.5 N
M$6 \$4 \$2 GROUND GROUND N L=0.8U W=2U AS=7.76P AD=7.76P PS=11.4U PD=11.4U
* device instance $7 r0 *1 22.75,21.65 P
M$7 VDD \$2 \$4 VDD P L=0.8U W=3U AS=8.7P AD=8.7P PS=11.8U PD=11.8U
* device instance $8 r0 *1 35.85,20.85 P
M$8 VDD IN2 \$2 VDD P L=0.8U W=3U AS=8.7P AD=8.7P PS=11.8U PD=11.8U
* device instance $9 r0 *1 12.15,19.85 P
M$9 \$3 \$6 \$2 VDD P L=0.8U W=3U AS=8.7P AD=5.25P PS=11.8U PD=6.5U
* device instance $10 r0 *1 16.45,19.85 P
M$10 \$4 IN1 \$3 VDD P L=0.8U W=3U AS=5.25P AD=8.7P PS=6.5U PD=11.8U
* device instance $11 r0 *1 4.05,19.6 P
M$11 \$6 IN1 VDD VDD P L=0.8U W=3U AS=8.7P AD=8.7P PS=11.8U PD=11.8U
* device instance $12 r0 *1 29.55,18 P
M$12 OUT1 \$3 VDD VDD P L=0.8U W=3U AS=8.7P AD=8.7P PS=11.8U PD=11.8U
.ENDS XNR200

* cell NND500
* pin IN1
* pin IN3
* pin IN2
* pin OUT1
* pin IN5
* pin IN4
* pin VDD
* pin GROUND
.SUBCKT NND500 IN1 IN3 IN2 OUT1 IN5 IN4 VDD GROUND
* device instance $1 r0 *1 4.4,4.65 N
M$1 \$8 IN5 GROUND GROUND N L=0.8U W=5.3U AS=15.37P AD=6.36P PS=16.4U PD=7.7U
* device instance $2 r0 *1 7.6,4.65 N
M$2 \$9 IN4 \$8 GROUND N L=0.8U W=5.3U AS=6.36P AD=8.215P PS=7.7U PD=8.4U
* device instance $3 r0 *1 11.5,4.65 N
M$3 \$10 IN3 \$9 GROUND N L=0.8U W=5.3U AS=8.215P AD=19.61P PS=8.4U PD=12.7U
* device instance $4 r0 *1 19.7,4.65 N
M$4 \$11 IN2 \$10 GROUND N L=0.8U W=5.3U AS=19.61P AD=3.445P PS=12.7U PD=6.6U
* device instance $5 r0 *1 21.8,4.65 N
M$5 OUT1 IN1 \$11 GROUND N L=0.8U W=5.3U AS=3.445P AD=23.1P PS=6.6U PD=21.1U
* device instance $6 r0 *1 6.05,19.05 P
M$6 OUT1 IN5 VDD VDD P L=0.8U W=6U AS=17.4P AD=9.6P PS=17.8U PD=9.2U
* device instance $7 r0 *1 10.05,19.05 P
M$7 VDD IN4 OUT1 VDD P L=0.8U W=6U AS=9.6P AD=9.6P PS=9.2U PD=9.2U
* device instance $8 r0 *1 14.05,19.05 P
M$8 OUT1 IN3 VDD VDD P L=0.8U W=6U AS=9.6P AD=11.1P PS=9.2U PD=9.7U
* device instance $9 r0 *1 18.55,19.05 P
M$9 VDD IN2 OUT1 VDD P L=0.8U W=6U AS=11.1P AD=9.9P PS=9.7U PD=9.3U
* device instance $10 r0 *1 22.65,19.05 P
M$10 OUT1 IN1 VDD VDD P L=0.8U W=6U AS=9.9P AD=17.4P PS=9.3U PD=17.8U
.ENDS NND500

* cell OAI400
* pin VDD
* pin IN1
* pin IN3
* pin OUT1
* pin IN4
* pin IN2
* pin GROUND
.SUBCKT OAI400 VDD IN1 IN3 OUT1 IN4 IN2 GROUND
* device instance $1 r0 *1 7.8,5.55 N
M$1 OUT1 IN2 \$3 GROUND N L=0.8U W=2.9U AS=8.41P AD=9.135P PS=11.6U PD=9.5U
* device instance $2 r0 *1 12.3,5.55 N
M$2 \$3 IN1 OUT1 GROUND N L=0.8U W=2.9U AS=9.135P AD=6.815P PS=9.5U PD=7.6U
* device instance $3 r0 *1 17.8,5.55 N
M$3 GROUND IN3 \$3 GROUND N L=0.8U W=2.9U AS=6.815P AD=4.64P PS=7.6U PD=6.1U
* device instance $4 r0 *1 21.8,5.55 N
M$4 \$3 IN4 GROUND GROUND N L=0.8U W=2.9U AS=4.64P AD=8.41P PS=6.1U PD=11.6U
* device instance $5 r0 *1 9.2,19 P
M$5 \$10 IN2 OUT1 VDD P L=0.8U W=5.5U AS=17.31P AD=2.75P PS=17.4U PD=6.5U
* device instance $6 r0 *1 11,19 P
M$6 VDD IN1 \$10 VDD P L=0.8U W=5.5U AS=2.75P AD=26.725P PS=6.5U PD=14.85U
* device instance $7 r0 *1 19.8,19 P
M$7 \$9 IN3 VDD VDD P L=0.8U W=5.5U AS=26.725P AD=3.025P PS=14.85U PD=6.6U
* device instance $8 r0 *1 21.7,19 P
M$8 \$9 IN4 OUT1 VDD P L=0.8U W=5.5U AS=17.31P AD=3.025P PS=17.4U PD=6.6U
.ENDS OAI400

* cell OR4100
* pin OUT1
* pin IN2
* pin IN3
* pin IN4
* pin IN1
* pin VDD
* pin GROUND
.SUBCKT OR4100 OUT1 IN2 IN3 IN4 IN1 VDD GROUND
* device instance $1 r0 *1 32.5,5.55 N
M$1 OUT1 \$2 GROUND GROUND N L=0.8U W=2U AS=7.76P AD=7.76P PS=11.4U PD=11.4U
* device instance $2 r0 *1 5.85,4.7 N
M$2 GROUND IN1 \$2 GROUND N L=0.8U W=3.6U AS=12.72P AD=13.23P PS=14.6U PD=10.95U
* device instance $3 r0 *1 14,4.7 N
M$3 \$2 IN2 GROUND GROUND N L=0.8U W=3.6U AS=13.23P AD=7.71P PS=10.95U PD=8.05U
* device instance $4 r0 *1 18.65,4.7 N
M$4 GROUND IN3 \$2 GROUND N L=0.8U W=3.6U AS=7.71P AD=5.76P PS=8.05U PD=6.8U
* device instance $5 r0 *1 22.65,4.7 N
M$5 \$2 IN4 GROUND GROUND N L=0.8U W=3.6U AS=5.76P AD=12.72P PS=6.8U PD=14.6U
* device instance $6 r0 *1 6.425,21.9 P
M$6 \$9 IN1 VDD VDD P L=0.8U W=15.1U AS=40.0525P AD=29.48P PS=33.7U PD=19.85U
* device instance $7 r0 *1 11.975,21.9 P
M$7 \$10 IN2 \$9 VDD P L=0.8U W=15.1U AS=29.48P AD=32.04P PS=19.85U PD=20.25U
* device instance $8 r0 *1 17.925,21.9 P
M$8 \$11 IN3 \$10 VDD P L=0.8U W=15.1U AS=32.04P AD=24.04P PS=20.25U PD=19U
* device instance $9 r0 *1 22.625,21.9 P
M$9 \$2 IN4 \$11 VDD P L=0.8U W=15.1U AS=24.04P AD=44.5175P PS=19U PD=36U
* device instance $10 r0 *1 32.5,18.5 P
M$10 OUT1 \$2 VDD VDD P L=0.8U W=3U AS=8.7P AD=9.3P PS=11.8U PD=12.2U
.ENDS OR4100

* cell OR2100
* pin OUT1
* pin IN1
* pin IN2
* pin VDD
* pin GROUND
.SUBCKT OR2100 OUT1 IN1 IN2 VDD GROUND
* device instance $1 r0 *1 4.25,4.1 N
M$1 \$3 IN2 GROUND GROUND N L=0.8U W=2U AS=7.76P AD=6.2P PS=11.4U PD=7.6U
* device instance $2 r0 *1 8.65,4.1 N
M$2 GROUND IN1 \$3 GROUND N L=0.8U W=2U AS=6.2P AD=4.38P PS=7.6U PD=6.2U
* device instance $3 r0 *1 13.05,4.1 N
M$3 OUT1 \$3 GROUND GROUND N L=0.8U W=2U AS=4.38P AD=11.4P PS=6.2U PD=14.2U
* device instance $4 r0 *1 4.75,20.1 P
M$4 \$7 IN2 VDD VDD P L=0.8U W=3.6U AS=10.44P AD=3.15P PS=13U PD=5.35U
* device instance $5 r0 *1 7.3,20.1 P
M$5 \$3 IN1 \$7 VDD P L=0.8U W=3.6U AS=3.15P AD=10.44P PS=5.35U PD=13U
* device instance $6 r0 *1 15.4,18.55 P
M$6 OUT1 \$3 VDD VDD P L=0.8U W=3.1U AS=8.99P AD=8.99P PS=12U PD=12U
.ENDS OR2100

* cell ADNR00
* pin OUT1
* pin IN2
* pin VDD
* pin IN1
* pin IN3
* pin GROUND
.SUBCKT ADNR00 OUT1 IN2 VDD IN1 IN3 GROUND
* device instance $1 r0 *1 6.85,5.55 N
M$1 \$8 IN2 GROUND GROUND N L=0.8U W=2.9U AS=8.41P AD=1.45P PS=11.6U PD=3.9U
* device instance $2 r0 *1 8.65,5.55 N
M$2 OUT1 IN1 \$8 GROUND N L=0.8U W=2.9U AS=1.45P AD=4.64P PS=3.9U PD=6.1U
* device instance $3 r0 *1 12.65,5.55 N
M$3 GROUND IN3 OUT1 GROUND N L=0.8U W=2.9U AS=4.64P AD=8.41P PS=6.1U PD=11.6U
* device instance $4 r0 *1 6.85,21.25 P
M$4 \$3 IN2 VDD VDD P L=0.8U W=5.8U AS=24.6P AD=9.28P PS=21.2U PD=9U
* device instance $5 r0 *1 10.85,21.25 P
M$5 VDD IN1 \$3 VDD P L=0.8U W=5.8U AS=9.28P AD=27.4P PS=9U PD=22U
* device instance $6 r0 *1 20.05,18.25 P
M$6 OUT1 IN3 \$3 VDD P L=0.8U W=5.8U AS=16.82P AD=16.82P PS=17.4U PD=17.4U
.ENDS ADNR00

* cell ORND00
* pin VDD
* pin IN1
* pin OUT1
* pin IN2
* pin IN3
* pin GROUND
.SUBCKT ORND00 VDD IN1 OUT1 IN2 IN3 GROUND
* device instance $1 r0 *1 10.35,5.1 N
M$1 \$7 IN3 GROUND GROUND N L=0.8U W=2.7U AS=7.83P AD=5.22P PS=11.2U
+ PD=5.66666666667U
* device instance $2 r0 *1 8.1,8.95 N
M$2 OUT1 IN2 \$7 GROUND N L=0.8U W=2.7U AS=5.22P AD=8.76P PS=5.66666666667U
+ PD=11.9U
* device instance $3 r0 *1 12.6,8.95 N
M$3 OUT1 IN1 \$7 GROUND N L=0.8U W=2.7U AS=5.22P AD=8.235P PS=5.66666666667U
+ PD=11.5U
* device instance $4 r0 *1 4.85,20.4 P
M$4 OUT1 IN3 VDD VDD P L=0.8U W=4.1U AS=11.89P AD=7.79P PS=14U PD=7.9U
* device instance $5 r0 *1 9.45,20.4 P
M$5 \$8 IN2 OUT1 VDD P L=0.8U W=4.1U AS=7.79P AD=2.05P PS=7.9U PD=5.1U
* device instance $6 r0 *1 11.25,20.4 P
M$6 VDD IN1 \$8 VDD P L=0.8U W=4.1U AS=2.05P AD=11.89P PS=5.1U PD=14U
.ENDS ORND00

* cell AND200
* pin VDD
* pin OUT1
* pin IN2
* pin IN1
* pin GROUND
.SUBCKT AND200 VDD OUT1 IN2 IN1 GROUND
* device instance $1 r0 *1 4.65,5.6 N
M$1 \$7 IN2 GROUND GROUND N L=0.8U W=2.4U AS=7.96P AD=2.16P PS=11.4U PD=4.2U
* device instance $2 r0 *1 7.25,5.6 N
M$2 \$6 IN1 \$7 GROUND N L=0.8U W=2.4U AS=2.16P AD=7.96P PS=4.2U PD=11.4U
* device instance $3 r0 *1 16.8,4.4 N
M$3 OUT1 \$6 GROUND GROUND N L=0.8U W=2U AS=7.76P AD=7.76P PS=11.4U PD=11.4U
* device instance $4 r0 *1 14.85,19.55 P
M$4 OUT1 \$6 VDD VDD P L=0.8U W=3U AS=4.935P AD=8.7P PS=6.3U PD=11.8U
* device instance $5 r0 *1 6.85,19.6 P
M$5 \$6 IN2 VDD VDD P L=0.8U W=3.1U AS=8.99P AD=4.96P PS=12U PD=6.3U
* device instance $6 r0 *1 10.85,19.6 P
M$6 VDD IN1 \$6 VDD P L=0.8U W=3.1U AS=4.96P AD=4.935P PS=6.3U PD=6.3U
.ENDS AND200

* cell NOR300
* pin VDD
* pin IN3
* pin OUT1
* pin IN1
* pin IN2
* pin GROUND
.SUBCKT NOR300 VDD IN3 OUT1 IN1 IN2 GROUND
* device instance $1 r0 *1 6.2,4.4 N
M$1 OUT1 IN1 GROUND GROUND N L=0.8U W=2.6U AS=7.54P AD=6.825P PS=11U PD=7.85U
* device instance $2 r0 *1 10.85,4.4 N
M$2 GROUND IN2 OUT1 GROUND N L=0.8U W=2.6U AS=6.825P AD=4.16P PS=7.85U PD=5.8U
* device instance $3 r0 *1 14.85,4.4 N
M$3 OUT1 IN3 GROUND GROUND N L=0.8U W=2.6U AS=4.16P AD=11.7P PS=5.8U PD=14.2U
* device instance $4 r0 *1 6.75,19.75 P
M$4 \$8 IN1 VDD VDD P L=0.8U W=8.5U AS=26.61P AD=8.5P PS=23.4U PD=10.5U
* device instance $5 r0 *1 9.55,19.75 P
M$5 \$7 IN2 \$8 VDD P L=0.8U W=8.5U AS=8.5P AD=16.575P PS=10.5U PD=12.4U
* device instance $6 r0 *1 14.25,19.75 P
M$6 OUT1 IN3 \$7 VDD P L=0.8U W=8.5U AS=16.575P AD=32.3P PS=12.4U PD=24.6U
.ENDS NOR300

* cell INVR00
* pin VDD
* pin OUT1
* pin IN1
* pin GROUND
.SUBCKT INVR00 VDD OUT1 IN1 GROUND
* device instance $1 r0 *1 5.2,5.55 N
M$1 OUT1 IN1 GROUND GROUND N L=0.8U W=2U AS=7.76P AD=7.76P PS=11.4U PD=11.4U
* device instance $2 r0 *1 5.2,18.5 P
M$2 OUT1 IN1 VDD VDD P L=0.8U W=3U AS=8.7P AD=9.3P PS=11.8U PD=12.2U
.ENDS INVR00

* cell DFCL11
* pin CLR
* pin Q
* pin C
* pin D
* pin QB
* pin VDD
* pin GROUND
.SUBCKT DFCL11 CLR Q C D QB VDD GROUND
* device instance $1 r0 *1 30.35,5.8 N
M$1 \$13 \$4 GROUND GROUND N L=0.8U W=2U AS=11.18P AD=15.28P PS=12.1U PD=11.7U
* device instance $2 r0 *1 37.65,5.8 N
M$2 \$16 CLR GROUND GROUND N L=0.8U W=2U AS=11.18P AD=3.2P PS=12.1U PD=5.2U
* device instance $3 r0 *1 41.65,5.8 N
M$3 \$4 \$3 \$16 GROUND N L=0.8U W=2U AS=3.2P AD=4.38P PS=5.2U PD=6.2U
* device instance $4 r0 *1 57.45,5.8 N
M$4 \$15 \$7 \$5 GROUND N L=0.8U W=2U AS=14.6P AD=4.6P PS=11.5U PD=6.6U
* device instance $5 r0 *1 62.85,5.8 N
M$5 \$15 CLR GROUND GROUND N L=0.8U W=2U AS=9.81P AD=4.6P PS=10.7U PD=6.6U
* device instance $6 r0 *1 68.65,5.8 N
M$6 \$7 \$6 GROUND GROUND N L=0.8U W=2U AS=9.81P AD=7.76P PS=10.7U PD=11.4U
* device instance $7 r0 *1 19.05,6.1 N
M$7 \$3 \$9 D GROUND N L=0.8U W=2U AS=7.5P AD=4.38P PS=11.2U PD=6.2U
* device instance $8 r0 *1 23.45,6.1 N
M$8 \$13 \$11 \$3 GROUND N L=0.8U W=2U AS=4.38P AD=15.28P PS=6.2U PD=11.7U
* device instance $9 r0 *1 46.05,6.1 N
M$9 \$6 \$11 \$4 GROUND N L=0.8U W=2U AS=4.38P AD=4.38P PS=6.2U PD=6.2U
* device instance $10 r0 *1 50.45,6.1 N
M$10 \$5 \$9 \$6 GROUND N L=0.8U W=2U AS=4.38P AD=14.6P PS=6.2U PD=11.5U
* device instance $11 r0 *1 77.15,6 N
M$11 GROUND \$7 QB GROUND N L=0.8U W=2.4U AS=7.96P AD=4.58P PS=11.4U PD=6.2U
* device instance $12 r0 *1 81.55,6 N
M$12 Q QB GROUND GROUND N L=0.8U W=2.4U AS=4.58P AD=7.96P PS=6.2U PD=11.4U
* device instance $13 r0 *1 4.15,6.1 N
M$13 GROUND C \$9 GROUND N L=0.8U W=2U AS=7.5P AD=4.12P PS=11.2U PD=6U
* device instance $14 r0 *1 8.35,6.1 N
M$14 \$11 \$9 GROUND GROUND N L=0.8U W=2U AS=4.12P AD=7.5P PS=6U PD=11.2U
* device instance $15 r0 *1 77.75,19.7 P
M$15 VDD \$7 QB VDD P L=0.8U W=4.4U AS=12.76P AD=7.205P PS=14.6U PD=7.8U
* device instance $16 r0 *1 81.75,19.8 P
M$16 Q QB VDD VDD P L=0.8U W=4.6U AS=7.205P AD=13.34P PS=7.8U PD=15U
* device instance $17 r0 *1 37.65,19.75 P
M$17 VDD CLR \$4 VDD P L=0.8U W=3U AS=8.7P AD=4.8P PS=11.8U PD=6.2U
* device instance $18 r0 *1 41.65,19.75 P
M$18 \$4 \$3 VDD VDD P L=0.8U W=3U AS=4.8P AD=5.4P PS=6.2U PD=6.6U
* device instance $19 r0 *1 46.05,19.75 P
M$19 \$6 \$9 \$4 VDD P L=0.8U W=3U AS=5.4P AD=5.4P PS=6.6U PD=6.6U
* device instance $20 r0 *1 50.45,19.75 P
M$20 \$5 \$11 \$6 VDD P L=0.8U W=3U AS=5.4P AD=5.25P PS=6.6U PD=6.5U
* device instance $21 r0 *1 54.75,19.75 P
M$21 VDD \$7 \$5 VDD P L=0.8U W=3U AS=5.25P AD=4.8P PS=6.5U PD=6.2U
* device instance $22 r0 *1 58.75,19.75 P
M$22 \$5 CLR VDD VDD P L=0.8U W=3U AS=4.8P AD=8.7P PS=6.2U PD=11.8U
* device instance $23 r0 *1 6.85,18.7 P
M$23 VDD C \$9 VDD P L=0.8U W=3U AS=8.7P AD=4.8P PS=11.8U PD=6.2U
* device instance $24 r0 *1 10.85,18.7 P
M$24 \$11 \$9 VDD VDD P L=0.8U W=3U AS=4.8P AD=8.7P PS=6.2U PD=11.8U
* device instance $25 r0 *1 19.05,18.7 P
M$25 \$3 \$11 D VDD P L=0.8U W=3U AS=8.7P AD=5.25P PS=11.8U PD=6.5U
* device instance $26 r0 *1 23.35,18.7 P
M$26 \$13 \$9 \$3 VDD P L=0.8U W=3U AS=5.25P AD=5.4P PS=6.5U PD=6.6U
* device instance $27 r0 *1 27.75,18.7 P
M$27 VDD \$4 \$13 VDD P L=0.8U W=3U AS=5.4P AD=8.7P PS=6.6U PD=11.8U
* device instance $28 r0 *1 69.65,19.25 P
M$28 \$7 \$6 VDD VDD P L=0.8U W=3U AS=8.7P AD=8.7P PS=11.8U PD=11.8U
.ENDS DFCL11

* cell DFFL11
* pin Q
* pin C
* pin D
* pin QB
* pin VDD
* pin GROUND
.SUBCKT DFFL11 Q C D QB VDD GROUND
* device instance $1 r0 *1 30.35,5.8 N
M$1 \$11 \$3 GROUND GROUND N L=0.8U W=2U AS=9.38P AD=15.28P PS=10.3U PD=11.7U
* device instance $2 r0 *1 35.85,5.8 N
M$2 \$3 \$2 GROUND GROUND N L=0.8U W=2U AS=9.38P AD=4.38P PS=10.3U PD=6.2U
* device instance $3 r0 *1 51.65,5.55 N
M$3 QB Q GROUND GROUND N L=0.8U W=2.5U AS=10.41P AD=16P PS=10.7U PD=12U
* device instance $4 r0 *1 57.45,5.55 N
M$4 Q \$4 GROUND GROUND N L=0.8U W=2.5U AS=10.41P AD=9.31P PS=10.7U PD=12.4U
* device instance $5 r0 *1 19.05,6.1 N
M$5 \$2 \$6 D GROUND N L=0.8U W=2U AS=7.5P AD=4.38P PS=11.2U PD=6.2U
* device instance $6 r0 *1 23.45,6.1 N
M$6 \$11 \$8 \$2 GROUND N L=0.8U W=2U AS=4.38P AD=15.28P PS=6.2U PD=11.7U
* device instance $7 r0 *1 40.25,6.1 N
M$7 \$4 \$8 \$3 GROUND N L=0.8U W=2U AS=4.38P AD=4.38P PS=6.2U PD=6.2U
* device instance $8 r0 *1 44.65,6.1 N
M$8 \$4 \$6 QB GROUND N L=0.8U W=2U AS=16P AD=4.38P PS=12U PD=6.2U
* device instance $9 r0 *1 4.15,6.1 N
M$9 GROUND C \$6 GROUND N L=0.8U W=2U AS=7.5P AD=4.12P PS=11.2U PD=6U
* device instance $10 r0 *1 8.35,6.1 N
M$10 \$8 \$6 GROUND GROUND N L=0.8U W=2U AS=4.12P AD=7.5P PS=6U PD=11.2U
* device instance $11 r0 *1 35.85,19.75 P
M$11 \$3 \$2 VDD VDD P L=0.8U W=3U AS=8.7P AD=5.4P PS=11.8U PD=6.6U
* device instance $12 r0 *1 40.25,19.75 P
M$12 \$4 \$6 \$3 VDD P L=0.8U W=3U AS=5.4P AD=5.4P PS=6.6U PD=6.6U
* device instance $13 r0 *1 44.65,19.75 P
M$13 QB \$8 \$4 VDD P L=0.8U W=3U AS=5.4P AD=7.95P PS=6.6U PD=8.3U
* device instance $14 r0 *1 48.95,20.65 P
M$14 VDD Q QB VDD P L=0.8U W=4.8U AS=7.95P AD=13.92P PS=8.3U PD=15.4U
* device instance $15 r0 *1 6.85,18.7 P
M$15 VDD C \$6 VDD P L=0.8U W=3U AS=8.7P AD=4.8P PS=11.8U PD=6.2U
* device instance $16 r0 *1 10.85,18.7 P
M$16 \$8 \$6 VDD VDD P L=0.8U W=3U AS=4.8P AD=8.7P PS=6.2U PD=11.8U
* device instance $17 r0 *1 19.05,18.7 P
M$17 \$2 \$8 D VDD P L=0.8U W=3U AS=8.7P AD=5.25P PS=11.8U PD=6.5U
* device instance $18 r0 *1 23.35,18.7 P
M$18 \$11 \$6 \$2 VDD P L=0.8U W=3U AS=5.25P AD=5.4P PS=6.5U PD=6.6U
* device instance $19 r0 *1 27.75,18.7 P
M$19 VDD \$3 \$11 VDD P L=0.8U W=3U AS=5.4P AD=8.7P PS=6.6U PD=11.8U
* device instance $20 r0 *1 57.25,18.4 P
M$20 Q \$4 VDD VDD P L=0.8U W=4.7U AS=14.83P AD=14.83P PS=15.8U PD=15.8U
.ENDS DFFL11

* cell MX2100
* pin OUT1
* pin D0
* pin D1
* pin S
* pin VDD
* pin GROUND
.SUBCKT MX2100 OUT1 D0 D1 S VDD GROUND
* device instance $1 r0 *1 11.85,6 N
M$1 \$5 \$3 D0 GROUND N L=0.8U W=2U AS=7.76P AD=4.38P PS=11.4U PD=6.2U
* device instance $2 r0 *1 16.25,6 N
M$2 D1 S \$5 GROUND N L=0.8U W=2U AS=4.38P AD=7.76P PS=6.2U PD=11.4U
* device instance $3 r0 *1 2.95,4.7 N
M$3 \$3 S GROUND GROUND N L=0.8U W=2U AS=7.76P AD=7.76P PS=11.4U PD=11.4U
* device instance $4 r0 *1 23.15,3.5 N
M$4 OUT1 \$5 GROUND GROUND N L=0.8U W=2U AS=7.76P AD=7.76P PS=11.4U PD=11.4U
* device instance $5 r0 *1 5.6,22.8 P
M$5 VDD S \$3 VDD P L=0.8U W=3U AS=12.15P AD=9.3P PS=14.1U PD=12.2U
* device instance $6 r0 *1 11.9,19.85 P
M$6 \$5 S D0 VDD P L=0.8U W=3U AS=8.7P AD=5.25P PS=11.8U PD=6.5U
* device instance $7 r0 *1 16.2,19.85 P
M$7 D1 \$3 \$5 VDD P L=0.8U W=3U AS=5.25P AD=8.7P PS=6.5U PD=11.8U
* device instance $8 r0 *1 23.55,21.65 P
M$8 VDD \$5 OUT1 VDD P L=0.8U W=3.1U AS=8.99P AD=8.99P PS=12U PD=12U
.ENDS MX2100

* cell AOI400
* pin VDD
* pin OUT1
* pin IN4
* pin IN1
* pin IN2
* pin IN3
* pin GROUND
.SUBCKT AOI400 VDD OUT1 IN4 IN1 IN2 IN3 GROUND
* device instance $1 r0 *1 5.5,5.55 N
M$1 \$10 IN1 OUT1 GROUND N L=0.8U W=2.9U AS=8.99P AD=1.45P PS=12U PD=3.9U
* device instance $2 r0 *1 7.3,5.55 N
M$2 \$10 IN2 GROUND GROUND N L=0.8U W=2.9U AS=17.725P AD=1.45P PS=12.65U PD=3.9U
* device instance $3 r0 *1 16.1,5.55 N
M$3 \$9 IN4 GROUND GROUND N L=0.8U W=2.9U AS=17.725P AD=1.595P PS=12.65U PD=4U
* device instance $4 r0 *1 18,5.55 N
M$4 OUT1 IN3 \$9 GROUND N L=0.8U W=2.9U AS=1.595P AD=8.41P PS=4U PD=11.6U
* device instance $5 r0 *1 5.5,19.4 P
M$5 VDD IN1 \$6 VDD P L=0.8U W=3.1U AS=8.99P AD=4.96P PS=12U PD=6.3U
* device instance $6 r0 *1 9.5,19.4 P
M$6 \$6 IN2 VDD VDD P L=0.8U W=3.1U AS=4.96P AD=4.96P PS=6.3U PD=6.3U
* device instance $7 r0 *1 13.5,19.4 P
M$7 \$6 IN4 OUT1 VDD P L=0.8U W=3.1U AS=9.505P AD=4.96P PS=9.7U PD=6.3U
* device instance $8 r0 *1 18,19.4 P
M$8 \$6 IN3 OUT1 VDD P L=0.8U W=3.1U AS=9.505P AD=8.99P PS=9.7U PD=12U
.ENDS AOI400

* cell NOR200
* pin VDD
* pin OUT1
* pin IN2
* pin IN1
* pin GROUND
.SUBCKT NOR200 VDD OUT1 IN2 IN1 GROUND
* device instance $1 r0 *1 4.25,5.05 N
M$1 OUT1 IN1 GROUND GROUND N L=0.8U W=2.1U AS=7.81P AD=6.25P PS=11.4U PD=7.6U
* device instance $2 r0 *1 8.65,5.05 N
M$2 OUT1 IN2 GROUND GROUND N L=0.8U W=2.1U AS=9.37P AD=6.25P PS=12.6U PD=7.6U
* device instance $3 r0 *1 5.35,18.75 P
M$3 \$6 IN1 VDD VDD P L=0.8U W=5.3U AS=15.37P AD=4.9025P PS=16.4U PD=7.15U
* device instance $4 r0 *1 8,18.75 P
M$4 OUT1 IN2 \$6 VDD P L=0.8U W=5.3U AS=4.9025P AD=15.37P PS=7.15U PD=16.4U
.ENDS NOR200

* cell NOR400
* pin OUT1
* pin IN2
* pin IN3
* pin IN4
* pin IN1
* pin VDD
* pin GROUND
.SUBCKT NOR400 OUT1 IN2 IN3 IN4 IN1 VDD GROUND
* device instance $1 r0 *1 5.85,4.7 N
M$1 GROUND IN1 OUT1 GROUND N L=0.8U W=3.6U AS=12.72P AD=13.23P PS=14.6U
+ PD=10.95U
* device instance $2 r0 *1 14,4.7 N
M$2 OUT1 IN2 GROUND GROUND N L=0.8U W=3.6U AS=13.23P AD=7.71P PS=10.95U PD=8.05U
* device instance $3 r0 *1 18.65,4.7 N
M$3 GROUND IN3 OUT1 GROUND N L=0.8U W=3.6U AS=7.71P AD=5.76P PS=8.05U PD=6.8U
* device instance $4 r0 *1 22.65,4.7 N
M$4 OUT1 IN4 GROUND GROUND N L=0.8U W=3.6U AS=5.76P AD=12.72P PS=6.8U PD=14.6U
* device instance $5 r0 *1 6.425,21.9 P
M$5 \$8 IN1 VDD VDD P L=0.8U W=15.1U AS=40.0525P AD=29.48P PS=33.7U PD=19.85U
* device instance $6 r0 *1 11.975,21.9 P
M$6 \$9 IN2 \$8 VDD P L=0.8U W=15.1U AS=29.48P AD=32.04P PS=19.85U PD=20.25U
* device instance $7 r0 *1 17.925,21.9 P
M$7 \$10 IN3 \$9 VDD P L=0.8U W=15.1U AS=32.04P AD=24.04P PS=20.25U PD=19U
* device instance $8 r0 *1 22.625,21.9 P
M$8 OUT1 IN4 \$10 VDD P L=0.8U W=15.1U AS=24.04P AD=51.0175P PS=19U PD=38.1U
.ENDS NOR400

* cell AND300
* pin VDD
* pin IN3
* pin IN2
* pin IN1
* pin OUT1
* pin GROUND
.SUBCKT AND300 VDD IN3 IN2 IN1 OUT1 GROUND
* device instance $1 r0 *1 4.1,5.6 N
M$1 \$8 IN3 GROUND GROUND N L=0.8U W=3U AS=8.85P AD=6P PS=11.9U PD=7U
* device instance $2 r0 *1 8.9,5.6 N
M$2 \$9 IN2 \$8 GROUND N L=0.8U W=3U AS=6P AD=1.95P PS=7U PD=4.3U
* device instance $3 r0 *1 11,5.6 N
M$3 \$4 IN1 \$9 GROUND N L=0.8U W=3U AS=1.95P AD=10.2P PS=4.3U PD=12.8U
* device instance $4 r0 *1 21,3.95 N
M$4 OUT1 \$4 GROUND GROUND N L=0.8U W=2U AS=7.76P AD=7.76P PS=11.4U PD=11.4U
* device instance $5 r0 *1 4.1,18.9 P
M$5 VDD IN3 \$4 VDD P L=0.8U W=3U AS=8.85P AD=4.875P PS=11.9U PD=6.25U
* device instance $6 r0 *1 8.15,18.9 P
M$6 \$4 IN2 VDD VDD P L=0.8U W=3U AS=4.875P AD=4.8P PS=6.25U PD=6.2U
* device instance $7 r0 *1 12.15,18.9 P
M$7 VDD IN1 \$4 VDD P L=0.8U W=3U AS=4.8P AD=4.8P PS=6.2U PD=6.2U
* device instance $8 r0 *1 16.15,18.9 P
M$8 OUT1 \$4 VDD VDD P L=0.8U W=3U AS=4.8P AD=8.7P PS=6.2U PD=11.8U
.ENDS AND300

* cell MX4100
* pin D0
* pin D3
* pin D2
* pin D1
* pin S0
* pin S1
* pin OUT1
* pin VDD
* pin GROUND
.SUBCKT MX4100 D0 D3 D2 D1 S0 S1 OUT1 VDD GROUND
* device instance $1 r0 *1 55.05,6 N
M$1 \$12 \$17 \$11 GROUND N L=0.8U W=2U AS=7.76P AD=4.38P PS=11.4U PD=6.2U
* device instance $2 r0 *1 59.45,6 N
M$2 \$13 S0 \$12 GROUND N L=0.8U W=2U AS=4.38P AD=7.76P PS=6.2U PD=11.4U
* device instance $3 r0 *1 5.65,1.7 N
M$3 \$7 D1 GROUND GROUND N L=0.8U W=2U AS=7.76P AD=6.18P PS=11.4U PD=8U
* device instance $4 r0 *1 7.55,6 N
M$4 \$8 S0 \$7 GROUND N L=0.8U W=2U AS=6.18P AD=4.38P PS=8U PD=6.2U
* device instance $5 r0 *1 11.95,6 N
M$5 \$9 \$17 \$8 GROUND N L=0.8U W=2U AS=4.38P AD=7.76P PS=6.2U PD=11.4U
* device instance $6 r0 *1 103.4,4.5 N
M$6 OUT1 \$5 GROUND GROUND N L=0.8U W=2U AS=7.76P AD=7.76P PS=11.4U PD=11.4U
* device instance $7 r0 *1 78.85,6 N
M$7 \$5 S1 \$12 GROUND N L=0.8U W=2U AS=7.76P AD=4.38P PS=11.4U PD=6.2U
* device instance $8 r0 *1 83.25,6 N
M$8 \$8 \$14 \$5 GROUND N L=0.8U W=2U AS=4.38P AD=7.76P PS=6.2U PD=11.4U
* device instance $9 r0 *1 48.05,3.8 N
M$9 \$11 D2 GROUND GROUND N L=0.8U W=2U AS=7.76P AD=7.96P PS=11.4U PD=11.6U
* device instance $10 r0 *1 35.55,3.8 N
M$10 \$17 S0 GROUND GROUND N L=0.8U W=2U AS=7.76P AD=7.96P PS=11.4U PD=11.6U
* device instance $11 r0 *1 18.95,3.8 N
M$11 \$9 D0 GROUND GROUND N L=0.8U W=2U AS=7.76P AD=7.96P PS=11.4U PD=11.6U
* device instance $12 r0 *1 94.65,2.6 N
M$12 \$14 S1 GROUND GROUND N L=0.8U W=2U AS=7.76P AD=9.95P PS=11.4U PD=13.2U
* device instance $13 r0 *1 66.45,3.8 N
M$13 \$13 D3 GROUND GROUND N L=0.8U W=2U AS=7.76P AD=7.96P PS=11.4U PD=11.6U
* device instance $14 r0 *1 7.6,19.85 P
M$14 \$8 \$17 \$7 VDD P L=0.8U W=3U AS=8.25P AD=5.25P PS=8.5U PD=6.5U
* device instance $15 r0 *1 11.9,19.85 P
M$15 \$9 S0 \$8 VDD P L=0.8U W=3U AS=5.25P AD=8.7P PS=6.5U PD=11.8U
* device instance $16 r0 *1 5.2,23.75 P
M$16 VDD D1 \$7 VDD P L=0.8U W=3U AS=8.25P AD=8.7P PS=8.5U PD=11.8U
* device instance $17 r0 *1 94.9,22.25 P
M$17 VDD S1 \$14 VDD P L=0.8U W=3U AS=10.5P AD=8.7P PS=13U PD=11.8U
* device instance $18 r0 *1 66.7,21.65 P
M$18 VDD D3 \$13 VDD P L=0.8U W=3U AS=8.7P AD=8.7P PS=11.8U PD=11.8U
* device instance $19 r0 *1 47.8,21.65 P
M$19 VDD D2 \$11 VDD P L=0.8U W=3U AS=8.7P AD=8.7P PS=11.8U PD=11.8U
* device instance $20 r0 *1 19.2,21.65 P
M$20 VDD D0 \$9 VDD P L=0.8U W=3U AS=8.7P AD=8.7P PS=11.8U PD=11.8U
* device instance $21 r0 *1 103.05,20.85 P
M$21 VDD \$5 OUT1 VDD P L=0.8U W=3U AS=8.7P AD=8.7P PS=11.8U PD=11.8U
* device instance $22 r0 *1 55.1,19.85 P
M$22 \$12 S0 \$11 VDD P L=0.8U W=3U AS=8.7P AD=5.25P PS=11.8U PD=6.5U
* device instance $23 r0 *1 59.4,19.85 P
M$23 \$13 \$17 \$12 VDD P L=0.8U W=3U AS=5.25P AD=8.7P PS=6.5U PD=11.8U
* device instance $24 r0 *1 35.3,21.65 P
M$24 VDD S0 \$17 VDD P L=0.8U W=3U AS=8.7P AD=8.7P PS=11.8U PD=11.8U
* device instance $25 r0 *1 78.9,19.85 P
M$25 \$5 \$14 \$12 VDD P L=0.8U W=3U AS=8.7P AD=5.25P PS=11.8U PD=6.5U
* device instance $26 r0 *1 83.2,19.85 P
M$26 \$8 S1 \$5 VDD P L=0.8U W=3U AS=5.25P AD=8.7P PS=6.5U PD=11.8U
.ENDS MX4100

* cell NND400
* pin VDD
* pin IN3
* pin IN4
* pin IN2
* pin IN1
* pin OUT1
* pin GROUND
.SUBCKT NND400 VDD IN3 IN4 IN2 IN1 OUT1 GROUND
* device instance $1 r0 *1 8,5.3 N
M$1 \$10 IN4 GROUND GROUND N L=0.8U W=4U AS=11.6P AD=4.9P PS=13.8U PD=6.45U
* device instance $2 r0 *1 11.25,5.3 N
M$2 \$9 IN3 \$10 GROUND N L=0.8U W=4U AS=4.9P AD=7.5P PS=6.45U PD=7.75U
* device instance $3 r0 *1 15.8,5.3 N
M$3 \$8 IN2 \$9 GROUND N L=0.8U W=4U AS=7.5P AD=3P PS=7.75U PD=5.5U
* device instance $4 r0 *1 18.1,5.3 N
M$4 OUT1 IN1 \$8 GROUND N L=0.8U W=4U AS=3P AD=13.2P PS=5.5U PD=14.6U
* device instance $5 r0 *1 6.15,18.45 P
M$5 VDD IN4 OUT1 VDD P L=0.8U W=4.8U AS=13.92P AD=7.68P PS=15.4U PD=8U
* device instance $6 r0 *1 10.15,18.45 P
M$6 OUT1 IN3 VDD VDD P L=0.8U W=4.8U AS=7.68P AD=7.68P PS=8U PD=8U
* device instance $7 r0 *1 14.15,18.45 P
M$7 VDD IN2 OUT1 VDD P L=0.8U W=4.8U AS=7.68P AD=9.12P PS=8U PD=8.6U
* device instance $8 r0 *1 18.75,18.45 P
M$8 OUT1 IN1 VDD VDD P L=0.8U W=4.8U AS=9.12P AD=13.92P PS=8.6U PD=15.4U
.ENDS NND400

* cell XOR300
* pin IN2
* pin IN1
* pin OUT1
* pin IN3
* pin VDD
* pin GROUND
.SUBCKT XOR300 IN2 IN1 OUT1 IN3 VDD GROUND
* device instance $1 r0 *1 53.75,6 N
M$1 \$7 \$12 \$3 GROUND N L=0.8U W=2U AS=7.76P AD=4.38P PS=11.4U PD=6.2U
* device instance $2 r0 *1 58.15,6 N
M$2 \$8 \$11 \$7 GROUND N L=0.8U W=2U AS=4.38P AD=7.76P PS=6.2U PD=11.4U
* device instance $3 r0 *1 12.1,6 N
M$3 \$4 \$10 \$2 GROUND N L=0.8U W=2U AS=7.76P AD=4.38P PS=11.4U PD=6.2U
* device instance $4 r0 *1 16.5,6 N
M$4 \$5 IN1 \$4 GROUND N L=0.8U W=2U AS=4.38P AD=7.76P PS=6.2U PD=11.4U
* device instance $5 r0 *1 29.55,5.45 N
M$5 \$11 \$4 GROUND GROUND N L=0.8U W=2U AS=7.76P AD=7.76P PS=11.4U PD=11.4U
* device instance $6 r0 *1 44.85,4.7 N
M$6 \$12 \$11 GROUND GROUND N L=0.8U W=2U AS=7.76P AD=7.76P PS=11.4U PD=11.4U
* device instance $7 r0 *1 3.2,4.7 N
M$7 \$10 IN1 GROUND GROUND N L=0.8U W=2U AS=7.76P AD=7.76P PS=11.4U PD=11.4U
* device instance $8 r0 *1 37.35,4.4 N
M$8 \$2 IN2 GROUND GROUND N L=0.8U W=2U AS=8.02P AD=10.1P PS=11.6U PD=13.2U
* device instance $9 r0 *1 79,4.4 N
M$9 \$3 IN3 GROUND GROUND N L=0.8U W=2U AS=8.02P AD=10.1P PS=11.6U PD=13.2U
* device instance $10 r0 *1 64.15,3.5 N
M$10 \$8 \$3 GROUND GROUND N L=0.8U W=2U AS=7.76P AD=7.76P PS=11.4U PD=11.4U
* device instance $11 r0 *1 71.2,5.45 N
M$11 OUT1 \$7 GROUND GROUND N L=0.8U W=2U AS=7.76P AD=7.76P PS=11.4U PD=11.4U
* device instance $12 r0 *1 22.5,3.5 N
M$12 \$5 \$2 GROUND GROUND N L=0.8U W=2U AS=7.76P AD=7.76P PS=11.4U PD=11.4U
* device instance $13 r0 *1 77.5,20.85 P
M$13 VDD IN3 \$3 VDD P L=0.8U W=3U AS=8.7P AD=8.7P PS=11.8U PD=11.8U
* device instance $14 r0 *1 35.85,20.85 P
M$14 VDD IN2 \$2 VDD P L=0.8U W=3U AS=8.7P AD=8.7P PS=11.8U PD=11.8U
* device instance $15 r0 *1 53.8,19.85 P
M$15 \$7 \$11 \$3 VDD P L=0.8U W=3U AS=8.7P AD=5.25P PS=11.8U PD=6.5U
* device instance $16 r0 *1 58.1,19.85 P
M$16 \$8 \$12 \$7 VDD P L=0.8U W=3U AS=5.25P AD=8.7P PS=6.5U PD=11.8U
* device instance $17 r0 *1 22.75,21.65 P
M$17 VDD \$2 \$5 VDD P L=0.8U W=3U AS=8.7P AD=8.7P PS=11.8U PD=11.8U
* device instance $18 r0 *1 29.55,18.05 P
M$18 \$11 \$4 VDD VDD P L=0.8U W=3.1U AS=8.99P AD=8.99P PS=12U PD=12U
* device instance $19 r0 *1 71.2,18.05 P
M$19 OUT1 \$7 VDD VDD P L=0.8U W=3.1U AS=8.99P AD=8.99P PS=12U PD=12U
* device instance $20 r0 *1 45.7,19.6 P
M$20 \$12 \$11 VDD VDD P L=0.8U W=3U AS=8.7P AD=8.7P PS=11.8U PD=11.8U
* device instance $21 r0 *1 12.15,19.85 P
M$21 \$4 IN1 \$2 VDD P L=0.8U W=3U AS=8.7P AD=5.25P PS=11.8U PD=6.5U
* device instance $22 r0 *1 16.45,19.85 P
M$22 \$5 \$10 \$4 VDD P L=0.8U W=3U AS=5.25P AD=8.7P PS=6.5U PD=11.8U
* device instance $23 r0 *1 4.05,19.6 P
M$23 \$10 IN1 VDD VDD P L=0.8U W=3U AS=8.7P AD=8.7P PS=11.8U PD=11.8U
* device instance $24 r0 *1 64.4,21.65 P
M$24 VDD \$3 \$8 VDD P L=0.8U W=3U AS=8.7P AD=8.7P PS=11.8U PD=11.8U
.ENDS XOR300

* cell NND200
* pin VDD
* pin OUT1
* pin IN2
* pin IN1
* pin GROUND
.SUBCKT NND200 VDD OUT1 IN2 IN1 GROUND
* device instance $1 r0 *1 4.65,5.6 N
M$1 \$6 IN2 GROUND GROUND N L=0.8U W=2.4U AS=7.96P AD=2.16P PS=11.4U PD=4.2U
* device instance $2 r0 *1 7.25,5.6 N
M$2 OUT1 IN1 \$6 GROUND N L=0.8U W=2.4U AS=2.16P AD=17.2P PS=4.2U PD=19.1U
* device instance $3 r0 *1 6.85,19.6 P
M$3 OUT1 IN2 VDD VDD P L=0.8U W=3.1U AS=8.99P AD=4.96P PS=12U PD=6.3U
* device instance $4 r0 *1 10.85,19.6 P
M$4 VDD IN1 OUT1 VDD P L=0.8U W=3.1U AS=4.96P AD=8.99P PS=6.3U PD=12U
.ENDS NND200

* cell NND300
* pin VDD
* pin IN3
* pin IN2
* pin OUT1
* pin IN1
* pin GROUND
.SUBCKT NND300 VDD IN3 IN2 OUT1 IN1 GROUND
* device instance $1 r0 *1 4.1,5.6 N
M$1 \$8 IN3 GROUND GROUND N L=0.8U W=3U AS=8.85P AD=6P PS=11.9U PD=7U
* device instance $2 r0 *1 8.9,5.6 N
M$2 \$7 IN2 \$8 GROUND N L=0.8U W=3U AS=6P AD=2.625P PS=7U PD=4.75U
* device instance $3 r0 *1 11.45,5.6 N
M$3 OUT1 IN1 \$7 GROUND N L=0.8U W=3U AS=2.625P AD=8.85P PS=4.75U PD=11.9U
* device instance $4 r0 *1 4.8,18.9 P
M$4 VDD IN3 OUT1 VDD P L=0.8U W=3U AS=8.85P AD=4.875P PS=11.9U PD=6.25U
* device instance $5 r0 *1 8.85,18.9 P
M$5 OUT1 IN2 VDD VDD P L=0.8U W=3U AS=4.875P AD=4.8P PS=6.25U PD=6.2U
* device instance $6 r0 *1 12.85,18.9 P
M$6 VDD IN1 OUT1 VDD P L=0.8U W=3U AS=4.8P AD=8.7P PS=6.2U PD=11.8U
.ENDS NND300

* cell SPAD00
* pin VDD
* pin PADIN
* pin OUT1
* pin GROUND
.SUBCKT SPAD00 VDD PADIN OUT1 GROUND
* device instance $1 r0 *1 134.6,156.55 RNW
R$1 PADIN OUT1 322.222222222 RNW
* device instance $2 r0 *1 143.45,216.039 dndiffpsub
D$2 GROUND OUT1 dndiffpsub A=1412.537785P P=258.043U
* device instance $4 r0 *1 64.554,178.875 dnwellpsub
D$4 GROUND PADIN dnwellpsub A=17287.631034P P=547.145U
* device instance $5 r0 *1 173.15,123.25 dpdiffnwell
D$5 OUT1 VDD dpdiffnwell A=362.802737P P=78.24U
* device instance $6 r0 *1 173.15,184.25 dpdiffnwell
D$6 PADIN VDD dpdiffnwell A=1258.756978P P=206.178U
.ENDS SPAD00

* cell PVDD01
* pin PVDD01,VDD
* pin GROUND
.SUBCKT PVDD01 PVDD01|VDD GROUND
* device instance $1 r0 *1 61.175,178.875 dnwellpsub
D$1 GROUND PVDD01|VDD dnwellpsub A=15025.368637P P=492.952U
.ENDS PVDD01

* cell PVSS01
* pin GROUND,PVSS01
.SUBCKT PVSS01 GROUND|PVSS01
* device instance $1 r0 *1 61.175,178.875 dnwellpsub
D$1 GROUND|PVSS01 GROUND|PVSS01 dnwellpsub A=15025.429648P P=493.164U
.ENDS PVSS01

* cell ASPAD00
* pin VDD
* pin PADIN
* pin GROUND
.SUBCKT ASPAD00 VDD PADIN GROUND
* device instance $1 r0 *1 134.6,156.55 RNW
R$1 PADIN \$4 322.222222222 RNW
* device instance $2 r0 *1 143.45,216.039 dndiffpsub
D$2 GROUND \$4 dndiffpsub A=1412.537785P P=258.043U
* device instance $4 r0 *1 64.554,178.875 dnwellpsub
D$4 GROUND PADIN dnwellpsub A=17287.631034P P=547.145U
* device instance $5 r0 *1 173.15,123.25 dpdiffnwell
D$5 \$4 VDD dpdiffnwell A=362.802737P P=78.24U
* device instance $6 r0 *1 173.15,184.25 dpdiffnwell
D$6 PADIN VDD dpdiffnwell A=1258.756978P P=206.178U
.ENDS ASPAD00
